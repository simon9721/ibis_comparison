| z41c.ibs * IBIS 5.0 Model
| 8Gb DDR4 SDRAM - Die Revision "R"
| This Model is valid for Commercial Temperature Range 0C<=Tc<=95C
| Valid for DDR4-1600/1866/2133/2400/2666/2933/3200 operation
| Models *_3200 are applicable for speed grade 3200 Mbps (-062) and below
| Part Number   VDD/VDDQ   Architecture   Package
| MT40A2G4SA   1.2V/1.2V   2Gb   x  4   78-Ball FBGA
| MT40A1G8SA   1.2V/1.2V   1Gb   x  8   78-Ball FBGA
| MT40A512M16TB   1.2V/1.2V   512Mb x 16   96-Ball FBGA
| MT40A2G4Z41C   1.2V/1.2V   2Gb   x  4   Bare Die
| MT40A1G8Z41C   1.2V/1.2V   1Gb   x  8   Bare Die
| MT40A512M16Z41C   1.2V/1.2V   512Mb x 16   Bare Die
[IBIS Ver]   5.0
[File Name]   z41c.ibs
[Date]   6/19/2022
[File Rev]   2.3
[Source]   From silicon level SPICE model at Micron Technology, Inc.
   For support contact your local Micron FAE/Sales contacts
   (more information at https://www.micron.com/support/sales-network)
[Notes]   Revision History:
   Rev 2.3: 6/19/2022
   - Matched C_comp with 4/25/2022 IOCAP measurements:
   Rev 2.2.2: 12/10/2021
   - Fixed PARITY pin x16 Package Component Model
   Rev 2.2.1: 9/1/2021
   - Added bare die component models
   Rev 2.1.1: 4/14/2021
   - Created Industrial Temperature Range Model
   Rev 2.1: 2/2/2021
   - Matched C_comp with 12/15/2020 IOCAP measurements:
   - Added x16 Package Component and Sparse Matrix Package Model
   Rev 2.0: 11/6/2020
   - Matched IV curves with 11/4/2020 measurements
   Rev 1.1: 4/23/2020
   - Corrected typos in this header
   - Models for ALERT, CLKIN and INPUT generated with new sw tool
   Rev 1.0: 4/13/2020
   - Initial pre-silicon model
   - All models were created from z41c SPF netlists.
   Notes:
   - The DQ_IN_ODT* models contain assumed input thresholds,
   the actual threshold values will depend on the VREFDQ
   level set by training
   - This IBIS file uses the Submodel keyword to model the
   DDR4 On-die Termination(ODT) characteristics.
   - The C_comp value in the DQ I/O model is set to match the
   input state of the DQ I/O as measured from the HSPICE model.
   The C_comp value decreases in the DQ/DQS Input ODT models.
   - L_pin values in the Pin sections are loop inductance and
   include the mutual inductance to appropriate POWER/GND
   return paths.  POWER/GND parasitics are modeled in the
   Package Models.
   - Typ and slow corner V-t curves in the following DQ* models
   are shifted relative to strong corner V-t curve
   to contain all 3 corners within appropriate V-t window
   Models   Typ   Slow   V-t duration
   DQ*_34_3200   -82ps   -210ps   440ps
   DQ*_40_3200   -82ps   -210ps   440ps
   DQ*_48_3200   -82ps   -210ps   440ps
   ALERT   -30ps   -80ps   300ps
   - Due to the shift in typ and slow corner, the V-t curves
   may overlap each other. This does not effect the accuracy
   of the IBIS data.
   - The NF_INPUT Model is for Non-functioning INPUT pins in the
   x8 package
   - The NF_DQ Model is for Non-functioning DQ pins in the
   x4 package
   See Micron IBIS Model Quality Report and Quality Checklist
   for full IQ details
[Disclaimer]  This software code and all associated documentation, comments
              or other information (collectively "Software") is provided
              "AS IS" without warranty of any kind. MICRON TECHNOLOGY, INC.
              ("MTI") EXPRESSLY DISCLAIMS ALL WARRANTIES EXPRESS OR IMPLIED,
              INCLUDING BUT NOT LIMITED TO, NONINFRINGEMENT OF THIRD PARTY
              RIGHTS, AND ANY IMPLIED WARRANTIES OF MERCHANTABILITY OR
              FITNESS FOR ANY PARTICULAR PURPOSE. MTI DOES NOT WARRANT THAT
              THE SOFTWARE WILL MEET YOUR REQUIREMENTS, OR THAT THE
              OPERATION OF THE SOFTWARE WILL BE UNINTERRUPTED OR ERROR-FREE.
              FURTHERMORE, MTI DOES NOT MAKE ANY REPRESENTATIONS REGARDING
              THE USE OR THE RESULTS OF THE USE OF THE SOFTWARE IN TERMS OF
              ITS CORRECTNESS, ACCURACY, RELIABILITY, OR OTHERWISE. THE
              ENTIRE RISK ARISING OUT OF USE OR PERFORMANCE OF THE SOFTWARE
              REMAINS WITH YOU. IN NO EVENT SHALL MTI, ITS AFFILIATED
              COMPANIES OR THEIR SUPPLIERS BE LIABLE FOR ANY DIRECT,
              INDIRECT, CONSEQUENTIAL, INCIDENTAL, OR SPECIAL DAMAGES
              (INCLUDING, WITHOUT LIMITATION, DAMAGES FOR LOSS OF PROFITS,
              BUSINESS INTERRUPTION, OR LOSS OF INFORMATION) ARISING OUT OF
              YOUR USE OF OR INABILITY TO USE THE SOFTWARE, EVEN IF MTI HAS
              BEEN ADVISED OF THE POSSIBILITY OF SUCH DAMAGES. Because some
              jurisdictions prohibit the exclusion or limitation of
              liability for consequential or incidental damages, the above
              limitation may not apply to you.
[Copyright]   Copyright 2022 Micron Technology, Inc. All rights reserved.
| COMPONENT: MT40A2G4SA (78-Ball FBGA, x4)
[Component]   MT40A2G4SA
[Package Model] z41c_78ball_pkg
[Manufacturer]  Micron Technology,Inc.
[Package]
|   typ   min   max
R_pkg   0.530   0.500   0.560
L_pkg   1.900nH   1.800nH   2.000nH
C_pkg   0.550pF   0.490pF   0.610pF
[Pin]   signal_name   model_name   R_pin   L_pin   C_pin   | TD_pin(ps)   Z_pin
A1   VDD   POWER
A2   VSSQ   GND
A3   NF   NF_DQ   0.564   2.066nH   0.578pF   | 34.569   59.761
A7   NF   NF_DQ   0.556   1.995nH   0.636pF   | 35.624   55.998
A8   VSSQ   GND
A9   VSS   GND
B1   VPP   POWER
B2   VDDQ   POWER
B3   DQS_c   DQS   0.511   2.024nH   0.578pF   | 34.211   59.175
B7   DQ1   DQ   0.544   1.944nH   0.602pF   | 34.222   56.812
B8   VDDQ   POWER
B9   ZQ   NC
C1   VDDQ   POWER
C2   DQ0   DQ   0.560   1.998nH   0.562pF   | 33.519   59.614
C3   DQS_t   DQS   0.511   2.108nH   0.576pF   | 34.841   60.497
C7   VDD   POWER
C8   VSS   GND
C9   VDDQ   POWER
D1   VSS   GND
D2   NC   NC
D3   DQ2   DQ   0.508   1.929nH   0.543pF   | 32.357   59.629
D7   DQ3   DQ   0.524   1.959nH   0.532pF   | 32.294   60.648
D8   NC   NC
D9   VSS   GND
E1   VSSL   GND
E2   VDDQ   POWER
E3   NC   NC
E7   NC   NC
E8   VDDQ   POWER
E9   VSS   GND
F1   VDDL   POWER
F2   NC   NC
F3   ODT   INPUT   0.442   1.988nH   0.418pF   | 28.817   68.994
F7   CK_t   CLKIN   0.473   1.953nH   0.494pF   | 31.065   62.863
F8   CK_c   CLKIN   0.483   1.947nH   0.524pF   | 31.930   60.982
F9   VDD   POWER
G1   VSS   GND
G2   NC   NC
G3   CKE   INPUT   0.440   2.053nH   0.397pF   | 28.542   71.941
G7   CS_n   INPUT   0.458   2.124nH   0.439pF   | 30.517   69.593
G8   NC   NC
G9   TEN   INPUT   0.487   2.673nH   0.715pF   | 43.723   61.139
H1   VDD   POWER
H2   WE_n_A14   INPUT   0.468   2.159nH   0.396pF   | 29.222   73.883
H3   ACT_n   INPUT   0.486   2.066nH   0.369pF   | 27.615   74.826
H7   CAS_n_A15   INPUT   0.472   2.090nH   0.395pF   | 28.748   72.695
H8   RAS_n_A16   INPUT   0.471   2.124nH   0.426pF   | 30.079   70.618
H9   VSS   GND
J1   VREFCA   POWER
J2   BG0   INPUT   0.483   2.377nH   0.393pF   | 30.558   77.788
J3   A10   INPUT   0.476   2.068nH   0.371pF   | 27.703   74.658
J7   A12_BC_n   INPUT   0.472   2.170nH   0.383pF   | 28.816   75.304
J8   BG1   INPUT   0.486   2.419nH   0.453pF   | 33.088   73.096
J9   VDD   POWER
K1   VSS   GND
K2   BA0   INPUT   0.469   2.247nH   0.433pF   | 31.186   72.041
K3   A4   INPUT   0.445   2.038nH   0.376pF   | 27.663   73.670
K7   A3   INPUT   0.445   2.091nH   0.365pF   | 27.636   75.656
K8   BA1   INPUT   0.469   2.344nH   0.405pF   | 30.805   76.080
K9   VSS   GND
L1   RESET_n   INPUT   0.378   1.900nH   0.576pF   | 33.081   57.422
L2   A6   INPUT   0.474   2.269nH   0.444pF   | 31.735   71.505
L3   A0   INPUT   0.464   2.242nH   0.453pF   | 31.851   70.380
L7   A1   INPUT   0.460   2.299nH   0.427pF   | 31.343   73.334
L8   A5   INPUT   0.477   2.336nH   0.429pF   | 31.663   73.775
L9   ALERT_n   ALERT   0.421   2.107nH   0.603pF   | 35.654   59.089
M1   VDD   POWER
M2   A8   INPUT   0.449   2.255nH   0.473pF   | 32.666   69.028
M3   A2   INPUT   0.475   2.303nH   0.457pF   | 32.444   70.994
M7   A9   INPUT   0.473   2.362nH   0.441pF   | 32.283   73.179
M8   A7   INPUT   0.455   2.340nH   0.457pF   | 32.692   71.586
M9   VPP   POWER
N1   VSS   GND
N2   A11   INPUT   0.492   2.507nH   0.499pF   | 35.354   70.909
N3   PARITY   INPUT   0.434   2.158nH   0.428pF   | 30.396   70.986
N7   NC   NC
N8   A13   INPUT   0.488   2.555nH   0.467pF   | 34.528   73.988
N9   VDD   POWER
|***********************PIN MAPPING*****************************************
[Pin Mapping]   pulldown_ref   pullup_ref   gnd_clamp_ref   power_clamp_ref ext_ref
A1   NC   VDD
A2   VSS   NC
A3   NC   NC   VSS   VDDQ
A7   NC   NC   VSS   VDDQ
A8   VSS   NC
A9   VSS   NC
B1   NC   VPP
B2   NC   VDDQ
B3   VSS   VDDQ   VSS   VDDQ
B7   VSS   VDDQ   VSS   VDDQ
B8   NC   VDDQ
B9   NC   NC
C1   NC   VDDQ
C2   VSS   VDDQ   VSS   VDDQ
C3   VSS   VDDQ   VSS   VDDQ
C7   NC   VDD
C8   VSS   NC
C9   NC   VDDQ
D1   VSS   NC
D2   NC   NC
D3   VSS   VDDQ   VSS   VDDQ
D7   VSS   VDDQ   VSS   VDDQ
D8   NC   NC
D9   VSS   NC
E1   VSSL   NC
E2   NC   VDDQ
E3   NC   NC
E7   NC   NC
E8   NC   VDDQ
E9   VSS   NC
F1   NC   VDDL
F2   NC   NC
F3   NC   NC   VSS   VDD
F7   NC   NC   VSS   VDD
F8   NC   NC   VSS   VDD
F9   NC   VDD
G1   VSS   NC
G2   NC   NC
G3   NC   NC   VSS   VDD
G7   NC   NC   VSS   VDD
G8   NC   NC
G9   NC   NC   VSS   VDD
H1   NC   VDD
H2   NC   NC   VSS   VDD
H3   NC   NC   VSS   VDD
H7   NC   NC   VSS   VDD
H8   NC   NC   VSS   VDD
H9   VSS   NC
J1   NC   VREFCA
J2   NC   NC   VSS   VDD
J3   NC   NC   VSS   VDD
J7   NC   NC   VSS   VDD
J8   NC   NC   VSS   VDD
J9   NC   VDD
K1   VSS   NC
K2   NC   NC   VSS   VDD
K3   NC   NC   VSS   VDD
K7   NC   NC   VSS   VDD
K8   NC   NC   VSS   VDD
K9   VSS   NC
L1   NC   NC   VSS   VDD
L2   NC   NC   VSS   VDD
L3   NC   NC   VSS   VDD
L7   NC   NC   VSS   VDD
L8   NC   NC   VSS   VDD
L9   VSS   VDDQ   VSS   VDDQ
M1   NC   VDD
M2   NC   NC   VSS   VDD
M3   NC   NC   VSS   VDD
M7   NC   NC   VSS   VDD
M8   NC   NC   VSS   VDD
M9   NC   VPP
N1   VSS   NC
N2   NC   NC   VSS   VDD
N3   NC   NC   VSS   VDD
N7   NC   NC
N8   NC   NC   VSS   VDD
N9   NC   VDD
|**********************DIFF PIN*********************************************
[Diff_pin]   inv_pin   vdiff   tdelay_typ   tdelay_min   tdelay_max
   C3   B3   0.000V   0ns   NA   NA
   F7   F8   0.250V   0ns   NA   NA
| COMPONENT: MT40A1G8SA (78-Ball FBGA, x8)
[Component]   MT40A1G8SA
[Package Model] z41c_78ball_pkg
[Manufacturer]  Micron Technology,Inc.
[Package]
|   typ   min   max
R_pkg   0.530   0.500   0.560
L_pkg   1.900nH   1.800nH   2.000nH
C_pkg   0.550pF   0.490pF   0.610pF
[Pin]   signal_name   model_name   R_pin   L_pin   C_pin   | TD_pin(ps)   Z_pin
A1   VDD   POWER
A2   VSSQ   GND
A3   TDQS_c   TDQS   0.564   2.066nH   0.578pF   | 34.569   59.761
A7   DM_n_DBI_n_TDQS_t DM_DBI_TDQS   0.556   1.995nH   0.636pF   | 35.624   55.998
A8   VSSQ   GND
A9   VSS   GND
B1   VPP   POWER
B2   VDDQ   POWER
B3   DQS_c   DQS   0.511   2.024nH   0.578pF   | 34.211   59.175
B7   DQ1   DQ   0.544   1.944nH   0.602pF   | 34.222   56.812
B8   VDDQ   POWER
B9   ZQ   NC
C1   VDDQ   POWER
C2   DQ0   DQ   0.560   1.998nH   0.562pF   | 33.519   59.614
C3   DQS_t   DQS   0.511   2.108nH   0.576pF   | 34.841   60.497
C7   VDD   POWER
C8   VSS   GND
C9   VDDQ   POWER
D1   VSS   GND
D2   DQ4   DQ   0.529   1.837nH   0.605pF   | 33.339   55.114
D3   DQ2   DQ   0.508   1.929nH   0.543pF   | 32.357   59.629
D7   DQ3   DQ   0.524   1.959nH   0.532pF   | 32.294   60.648
D8   DQ5   DQ   0.529   1.955nH   0.601pF   | 34.294   57.019
D9   VSS   GND
E1   VSSL   GND
E2   VDDQ   POWER
E3   DQ6   DQ   0.509   2.042nH   0.492pF   | 31.691   64.449
E7   DQ7   DQ   0.505   1.994nH   0.493pF   | 31.343   63.620
E8   VDDQ   POWER
E9   VSS   GND
F1   VDDL   POWER
F2   NC   NC
F3   ODT   INPUT   0.442   1.988nH   0.418pF   | 28.817   68.994
F7   CK_t   CLKIN   0.473   1.953nH   0.494pF   | 31.065   62.863
F8   CK_c   CLKIN   0.483   1.947nH   0.524pF   | 31.930   60.982
F9   VDD   POWER
G1   VSS   GND
G2   NC   NC
G3   CKE   INPUT   0.440   2.053nH   0.397pF   | 28.542   71.941
G7   CS_n   INPUT   0.458   2.124nH   0.439pF   | 30.517   69.593
G8   NC   NC
G9   TEN   INPUT   0.487   2.673nH   0.715pF   | 43.723   61.139
H1   VDD   POWER
H2   WE_n_A14   INPUT   0.468   2.159nH   0.396pF   | 29.222   73.883
H3   ACT_n   INPUT   0.486   2.066nH   0.369pF   | 27.615   74.826
H7   CAS_n_A15   INPUT   0.472   2.090nH   0.395pF   | 28.748   72.695
H8   RAS_n   INPUT   0.471   2.124nH   0.426pF   | 30.079   70.618
H9   VSS   GND
J1   VREFCA   POWER
J2   BG0   INPUT   0.483   2.377nH   0.393pF   | 30.558   77.788
J3   A10   INPUT   0.476   2.068nH   0.371pF   | 27.703   74.658
J7   A12_BC_n   INPUT   0.472   2.170nH   0.383pF   | 28.816   75.304
J8   BG1   INPUT   0.486   2.419nH   0.453pF   | 33.088   73.096
J9   VDD   POWER
K1   VSS   GND
K2   BA0   INPUT   0.469   2.247nH   0.433pF   | 31.186   72.041
K3   A4   INPUT   0.445   2.038nH   0.376pF   | 27.663   73.670
K7   A3   INPUT   0.445   2.091nH   0.365pF   | 27.636   75.656
K8   BA1   INPUT   0.469   2.344nH   0.405pF   | 30.805   76.080
K9   VSS   GND
L1   RESET_n   INPUT   0.378   1.900nH   0.576pF   | 33.081   57.422
L2   A6   INPUT   0.474   2.269nH   0.444pF   | 31.735   71.505
L3   A0   INPUT   0.464   2.242nH   0.453pF   | 31.851   70.380
L7   A1   INPUT   0.460   2.299nH   0.427pF   | 31.343   73.334
L8   A5   INPUT   0.477   2.336nH   0.429pF   | 31.663   73.775
L9   ALERT_n   ALERT   0.421   2.107nH   0.603pF   | 35.654   59.089
M1   VDD   POWER
M2   A8   INPUT   0.449   2.255nH   0.473pF   | 32.666   69.028
M3   A2   INPUT   0.475   2.303nH   0.457pF   | 32.444   70.994
M7   A9   INPUT   0.473   2.362nH   0.441pF   | 32.283   73.179
M8   A7   INPUT   0.455   2.340nH   0.457pF   | 32.692   71.586
M9   VPP   POWER
N1   VSS   GND
N2   A11   INPUT   0.492   2.507nH   0.499pF   | 35.354   70.909
N3   PARITY   INPUT   0.434   2.158nH   0.428pF   | 30.396   70.986
N7   NC   NC
N8   A13   INPUT   0.488   2.555nH   0.467pF   | 34.528   73.988
N9   VDD   POWER
|***********************PIN MAPPING*****************************************
[Pin Mapping]   pulldown_ref   pullup_ref   gnd_clamp_ref   power_clamp_ref ext_ref
A1   NC   VDD
A2   VSS   NC
A3   VSS   VDDQ   VSS   VDDQ
A7   VSS   VDDQ   VSS   VDDQ
A8   VSS   NC
A9   VSS   NC
B1   NC   VPP
B2   NC   VDDQ
B3   VSS   VDDQ   VSS   VDDQ
B7   VSS   VDDQ   VSS   VDDQ
B8   NC   VDDQ
B9   NC   NC
C1   NC   VDDQ
C2   VSS   VDDQ   VSS   VDDQ
C3   VSS   VDDQ   VSS   VDDQ
C7   NC   VDD
C8   VSS   NC
C9   NC   VDDQ
D1   VSS   NC
D2   VSS   VDDQ   VSS   VDDQ
D3   VSS   VDDQ   VSS   VDDQ
D7   VSS   VDDQ   VSS   VDDQ
D8   VSS   VDDQ   VSS   VDDQ
D9   VSS   NC
E1   VSSL   NC
E2   NC   VDDQ
E3   VSS   VDDQ   VSS   VDDQ
E7   VSS   VDDQ   VSS   VDDQ
E8   NC   VDDQ
E9   VSS   NC
F1   NC   VDDL
F2   NC   NC
F3   NC   NC   VSS   VDD
F7   NC   NC   VSS   VDD
F8   NC   NC   VSS   VDD
F9   NC   VDD
G1   VSS   NC
G2   NC   NC
G3   NC   NC   VSS   VDD
G7   NC   NC   VSS   VDD
G8   NC   NC
G9   NC   NC   VSS   VDD
H1   NC   VDD
H2   NC   NC   VSS   VDD
H3   NC   NC   VSS   VDD
H7   NC   NC   VSS   VDD
H8   NC   NC   VSS   VDD
H9   VSS   NC
J1   NC   VREFCA
J2   NC   NC   VSS   VDD
J3   NC   NC   VSS   VDD
J7   NC   NC   VSS   VDD
J8   NC   NC   VSS   VDD
J9   NC   VDD
K1   VSS   NC
K2   NC   NC   VSS   VDD
K3   NC   NC   VSS   VDD
K7   NC   NC   VSS   VDD
K8   NC   NC   VSS   VDD
K9   VSS   NC
L1   NC   NC   VSS   VDD
L2   NC   NC   VSS   VDD
L3   NC   NC   VSS   VDD
L7   NC   NC   VSS   VDD
L8   NC   NC   VSS   VDD
L9   VSS   VDDQ   VSS   VDDQ
M1   NC   VDD
M2   NC   NC   VSS   VDD
M3   NC   NC   VSS   VDD
M7   NC   NC   VSS   VDD
M8   NC   NC   VSS   VDD
M9   NC   VPP
N1   VSS   NC
N2   NC   NC   VSS   VDD
N3   NC   NC   VSS   VDD
N7   NC   NC
N8   NC   NC   VSS   VDD
N9   NC   VDD
|**********************DIFF PIN*********************************************
[Diff_pin]   inv_pin   vdiff   tdelay_typ   tdelay_min   tdelay_max
   C3   B3   0.000V   0ns   NA   NA
   F7   F8   0.250V   0ns   NA   NA
| COMPONENT: MT40A512M16TB (96-Ball FBGA, x16)
[Component]   MT40A512M16TB
[Package Model] z41c_96ball_pkg
[Manufacturer]  Micron Technology,Inc.
[Package]
|   typ   min   max
R_pkg   0.505   0.450   0.560
L_pkg   1.950nH   1.670nH   2.230nH
C_pkg   0.545pF   0.485pF   0.605pF
[Pin]   signal_name   model_name   R_pin   L_pin   C_pin   | TD_pin(ps)   Z_pin
A1   VDDQ   POWER
A2   VSSQ   GND
A3   DQ8   DQ   0.510   1.843nH   0.567pF   | 32.326   57.008
A7   UDQS_c   DQS   0.490   1.987nH   0.534pF   | 32.567   60.999
A8   VSSQ   GND
A9   VDDQ   POWER
B1   VPP   POWER
B2   VSS   GND
B3   VDD   POWER
B7   UDQS_t   DQS   0.486   1.970nH   0.528pF   | 32.254   61.073
B8   DQ9   DQ   0.520   1.825nH   0.575pF   | 32.390   56.345
B9   VDD   POWER
C1   VDDQ   POWER
C2   DQ12   DQ   0.478   1.669nH   0.527pF   | 29.662   56.273
C3   DQ10   DQ   0.503   1.908nH   0.550pF   | 32.397   58.904
C7   DQ11   DQ   0.465   1.788nH   0.532pF   | 30.842   57.985
C8   DQ13   DQ   0.485   1.725nH   0.547pF   | 30.722   56.153
C9   VSSQ   GND
D1   VDD   POWER
D2   VSSQ   GND
D3   DQ14   DQ   0.466   1.879nH   0.487pF   | 30.254   62.110
D7   DQ15   DQ   0.457   1.695nH   0.500pF   | 29.107   58.239
D8   VSSQ   GND
D9   VDDQ   POWER
E1   VSS   GND
E2   UDM_n_UDBI_n   DM_DBI   0.515   1.893nH   0.501pF   | 30.810   61.444
E3   VSSQ   GND
E7   LDM_n_LDBI_n   DM_DBI   0.536   1.960nH   0.551pF   | 32.862   59.636
E8   VSSQ   GND
E9   VSS   GND
F1   VSSQ   GND
F2   VDDQ   POWER
F3   LDQS_c   DQS   0.495   2.087nH   0.471pF   | 31.360   66.541
F7   DQ1   DQ   0.513   2.016nH   0.539pF   | 32.972   61.131
F8   VDDQ   POWER
F9   ZQ   NC
G1   VDDQ   POWER
G2   DQ0   DQ   0.502   1.833nH   0.541pF   | 31.508   58.190
G3   LDQS_t   DQS   0.495   2.015nH   0.498pF   | 31.691   63.597
G7   VDD   POWER
G8   VSS   GND
G9   VDDQ   POWER
H1   VSSQ   GND
H2   DQ4   DQ   0.556   1.927nH   0.605pF   | 34.138   56.453
H3   DQ2   DQ   0.493   1.773nH   0.506pF   | 29.949   59.201
H7   DQ3   DQ   0.520   2.222nH   0.518pF   | 33.942   65.471
H8   DQ5   DQ   0.519   1.897nH   0.569pF   | 32.867   57.713
H9   VSSQ   GND
J1   VDDL   POWER
J2   VDDQ   POWER
J3   DQ6   DQ   0.499   2.047nH   0.520pF   | 32.626   62.756
J7   DQ7   DQ   0.498   1.776nH   0.513pF   | 30.182   58.837
J8   VDDQ   POWER
J9   VDD   POWER
K1   VSSL   GND
K2   CKE   INPUT   0.506   2.407nH   0.489pF   | 34.300   70.180
K3   ODT   INPUT   0.505   2.031nH   0.423pF   | 29.318   69.280
K7   CK_t   CLKIN   0.507   2.124nH   0.497pF   | 32.499   65.368
K8   CK_c   CLKIN   0.508   2.014nH   0.512pF   | 32.124   62.688
K9   VSS   GND
L1   VDD   POWER
L2   WE_n_A14   INPUT   0.502   2.424nH   0.468pF   | 33.685   71.952
L3   ACT_n   INPUT   0.532   2.345nH   0.426pF   | 31.601   74.194
L7   CS_n   INPUT   0.504   2.206nH   0.444pF   | 31.307   70.477
L8   RAS_n   INPUT   0.514   2.387nH   0.514pF   | 35.023   68.145
L9   VDD   POWER
M1   VREFCA   POWER
M2   BG0   INPUT   0.523   2.544nH   0.494pF   | 35.446   71.760
M3   A10   INPUT   0.532   2.494nH   0.486pF   | 34.795   71.662
M7   A12_BC_n   INPUT   0.511   2.384nH   0.445pF   | 32.571   73.180
M8   CAS_n_A15   INPUT   0.519   2.448nH   0.493pF   | 34.727   70.493
M9   VSS   GND
N1   VSS   GND
N2   BA0   INPUT   0.513   2.506nH   0.558pF   | 37.402   67.005
N3   A4   INPUT   0.522   2.466nH   0.507pF   | 35.353   69.767
N7   A3   INPUT   0.516   2.438nH   0.510pF   | 35.254   69.142
N8   BA1   INPUT   0.508   2.508nH   0.536pF   | 36.671   68.398
N9   TEN   INPUT   0.508   2.257nH   0.757pF   | 41.349   54.593
P1   RESET_n   INPUT   0.551   2.247nH   0.793pF   | 42.215   53.229
P2   A6   INPUT   0.517   2.523nH   0.520pF   | 36.232   69.641
P3   A0   INPUT   0.512   2.494nH   0.504pF   | 35.439   70.365
P7   A1   INPUT   0.511   2.557nH   0.512pF   | 36.198   70.645
P8   A5   INPUT   0.511   2.608nH   0.525pF   | 36.992   70.509
P9   ALERT_n   ALERT   0.599   2.631nH   0.822pF   | 46.497   56.575
R1   VDD   POWER
R2   A8   INPUT   0.552   2.835nH   0.568pF   | 40.144   70.626
R3   A2   INPUT   0.484   2.501nH   0.518pF   | 35.997   69.475
R7   A9   INPUT   0.483   2.627nH   0.532pF   | 37.376   70.284
R8   A7   INPUT   0.553   3.001nH   0.587pF   | 41.970   71.510
R9   VPP   POWER
T1   VSS   GND
T2   A11   INPUT   0.613   3.166nH   0.625pF   | 44.494   71.145
T3   PARITY   INPUT   0.541   2.768nH   0.548pF   | 38.951   71.073
T7   NC   NC
T8   A13   INPUT   0.608   3.255nH   0.622pF   | 45.013   72.319
T9   VDD   POWER
|***********************PIN MAPPING*****************************************
[Pin Mapping]   pulldown_ref   pullup_ref   gnd_clamp_ref   power_clamp_ref ext_ref
A1   NC   VDDQ
A2   VSS   NC
A3   VSS   VDDQ   VSS   VDDQ
A7   VSS   VDDQ   VSS   VDDQ
A8   VSS   NC
A9   NC   VDDQ
B1   NC   VPP
B2   VSS   NC
B3   NC   VDD
B7   VSS   VDDQ   VSS   VDDQ
B8   VSS   VDDQ   VSS   VDDQ
B9   NC   VDD
C1   NC   VDDQ
C2   VSS   VDDQ   VSS   VDDQ
C3   VSS   VDDQ   VSS   VDDQ
C7   VSS   VDDQ   VSS   VDDQ
C8   VSS   VDDQ   VSS   VDDQ
C9   VSS   NC
D1   NC   VDD
D2   VSS   NC
D3   VSS   VDDQ   VSS   VDDQ
D7   VSS   VDDQ   VSS   VDDQ
D8   VSS   NC
D9   NC   VDDQ
E1   VSS   NC
E2   VSS   VDDQ   VSS   VDDQ
E3   VSS   NC
E7   VSS   VDDQ   VSS   VDDQ
E8   VSS   NC
E9   VSS   NC
F1   VSS   NC
F2   NC   VDDQ
F3   VSS   VDDQ   VSS   VDDQ
F7   VSS   VDDQ   VSS   VDDQ
F8   NC   VDDQ
F9   NC   NC
G1   NC   VDDQ
G2   VSS   VDDQ   VSS   VDDQ
G3   VSS   VDDQ   VSS   VDDQ
G7   NC   VDD
G8   VSS   NC
G9   NC   VDDQ
H1   VSS   NC
H2   VSS   VDDQ   VSS   VDDQ
H3   VSS   VDDQ   VSS   VDDQ
H7   VSS   VDDQ   VSS   VDDQ
H8   VSS   VDDQ   VSS   VDDQ
H9   VSS   NC
J1   NC   VDDL
J2   NC   VDDQ
J3   VSS   VDDQ   VSS   VDDQ
J7   VSS   VDDQ   VSS   VDDQ
J8   NC   VDDQ
J9   NC   VDD
K1   VSSL   NC
K2   NC   NC   VSS   VDD
K3   NC   NC   VSS   VDD
K7   NC   NC   VSS   VDD
K8   NC   NC   VSS   VDD
K9   VSS   NC
L1   NC   VDD
L2   NC   NC   VSS   VDD
L3   NC   NC   VSS   VDD
L7   NC   NC   VSS   VDD
L8   NC   NC   VSS   VDD
L9   NC   VDD
M1   NC   VREFCA
M2   NC   NC   VSS   VDD
M3   NC   NC   VSS   VDD
M7   NC   NC   VSS   VDD
M8   NC   NC   VSS   VDD
M9   VSS   NC
N1   VSS   NC
N2   NC   NC   VSS   VDD
N3   NC   NC   VSS   VDD
N7   NC   NC   VSS   VDD
N8   NC   NC   VSS   VDD
N9   NC   NC   VSS   VDD
P1   NC   NC   VSS   VDD
P2   NC   NC   VSS   VDD
P3   NC   NC   VSS   VDD
P7   NC   NC   VSS   VDD
P8   NC   NC   VSS   VDD
P9   VSS   VDDQ   VSS   VDDQ
R1   NC   VDD
R2   NC   NC   VSS   VDD
R3   NC   NC   VSS   VDD
R7   NC   NC   VSS   VDD
R8   NC   NC   VSS   VDD
R9   NC   VPP
T1   VSS   NC
T2   NC   NC   VSS   VDD
T3   NC   NC   VSS   VDD
T7   NC   NC
T8   NC   NC   VSS   VDD
T9   NC   VDD
|**********************DIFF PIN*********************************************
[Diff_pin]   inv_pin   vdiff   tdelay_typ   tdelay_min   tdelay_max
   B7   A7   0.000V   0ns   NA   NA
   G3   F3   0.000V   0ns   NA   NA
   K7   K8   0.250V   0ns   NA   NA
| COMPONENT: MT40A2G4Z41C (Bare Die, x4)
[Component]   MT40A2G4Z41C
[Manufacturer]  Micron Technology,Inc.
[Package]
|   typ   min   max
R_pkg   0.001   0.001   0.001
L_pkg   0.001nH   0.001nH   0.001nH
C_pkg   0.001pF   0.001pF   0.001pF
[Pin]   signal_name   model_name   R_pin   L_pin   C_pin
1   VPP   POWER
2   VSS   GND
3   VDD   POWER
4   VDDQ   POWER
5   VSSQ   GND
6   NC   NC
7   VDDQ   POWER
8   NC   NC
9   VSSQ   GND
10   NC   NC
11   VDDQ   POWER
12   NC   NC
13   VSSQ   GND
14   NF   NF_DQ
15   VDDQ   POWER
16   VDD   POWER
17   VSS   GND
18   VSSQ   GND
19   DQS_c   DQS
20   DQS_t   DQS
21   VDDQ   POWER
22   DQ0   DQ
23   VSSQ   GND
24   VSS   GND
25   VDD   POWER
26   VDDQ   POWER
27   DQ2   DQ
28   VSSQ   GND
29   NC   NC
30   VDDQ   POWER
31   NC   NC
32   VSSQ   GND
33   VSS   GND
34   VDD   POWER
35   VSSDL   GND
36   VDDL   POWER
37   VDDL   POWER
38   VSSDL   GND
39   VDD   POWER
40   ODT   INPUT
41   CKE   INPUT
42   WE_n_A14   INPUT
43   ACT_n   INPUT
44   VREFCA   POWER
45   BG0   INPUT
46   A10   INPUT
47   BA0   INPUT
48   A4   INPUT
49   VSS   GND
50   A6   INPUT
51   A0   INPUT
52   A8   INPUT
53   A2   INPUT
54   A11   INPUT
55   PARITY   INPUT
56   RESET_n   INPUT
57   VDD   POWER
58   VDD   POWER
59   VDD   POWER
60   VSS   GND
61   VSS   GND
62   VDD   POWER
63   VSSQ   GND
64   NC   NC
65   NC   NC
66   VDDQ   POWER
67   NC   NC
68   VSSQ   GND
69   VSS   GND
70   VDD   POWER
71   VDDQ   POWER
72   NC   NC
73   VSSQ   GND
74   NC   NC
75   VDDQ   POWER
76   NC   NC
77   VSSQ   GND
78   VDD   POWER
79   ZQ   INPUT
80   VDDQ   POWER
81   VSSQ   GND
82   NF   NF_DQ
83   VDDQ   POWER
84   DQ1   DQ
85   VSSQ   GND
86   DQ3   DQ
87   VDDQ   POWER
88   NC   NC
89   VSSQ   GND
90   NC   NC
91   VDDQ   POWER
92   VDD   POWER
93   VDD   POWER
94   VSS   GND
95   VSS   GND
96   CK_t   CLKIN
97   CK_c   CLKIN
98   VSS   GND
99   CS_n   INPUT
100   RAS_n_A16   INPUT
101   CAS_n_A15   INPUT
102   BG1   INPUT
103   A12_BC_n   INPUT
104   BA1   INPUT
105   A3   INPUT
106   VDD   POWER
107   A5   INPUT
108   A1   INPUT
109   A7   INPUT
110   A9   INPUT
111   A13   INPUT
112   NC   NC
113   TEN   INPUT
114   ALERT_n   ALERT
115   VSS   GND
116   VSS   GND
117   VPP   POWER
118   VSS   GND
|**********************DIFF PIN*********************************************
[Diff_pin]   inv_pin   vdiff   tdelay_typ   tdelay_min   tdelay_max
   20   19   0.000V   0ns   NA   NA
   96   97   0.250V   0ns   NA   NA
| COMPONENT: MT40A1G8Z41C (Bare Die, x8)
[Component]   MT40A1G8Z41C
[Manufacturer]  Micron Technology,Inc.
[Package]
|   typ   min   max
R_pkg   0.001   0.001   0.001
L_pkg   0.001nH   0.001nH   0.001nH
C_pkg   0.001pF   0.001pF   0.001pF
[Pin]   signal_name   model_name   R_pin   L_pin   C_pin
1   VPP   POWER
2   VSS   GND
3   VDD   POWER
4   VDDQ   POWER
5   VSSQ   GND
6   NC   NC
7   VDDQ   POWER
8   NC   NC
9   VSSQ   GND
10   NC   NC
11   VDDQ   POWER
12   NC   NC
13   VSSQ   GND
14   TDQS_c   TDQS
15   VDDQ   POWER
16   VDD   POWER
17   VSS   GND
18   VSSQ   GND
19   DQS_c   DQS
20   DQS_t   DQS
21   VDDQ   POWER
22   DQ0   DQ
23   VSSQ   GND
24   VSS   GND
25   VDD   POWER
26   VDDQ   POWER
27   DQ2   DQ
28   VSSQ   GND
29   DQ6   DQ
30   VDDQ   POWER
31   DQ4   DQ
32   VSSQ   GND
33   VSS   GND
34   VDD   POWER
35   VSSDL   GND
36   VDDL   POWER
37   VDDL   POWER
38   VSSDL   GND
39   VDD   POWER
40   ODT   INPUT
41   CKE   INPUT
42   WE_n_A14   INPUT
43   ACT_n   INPUT
44   VREFCA   POWER
45   BG0   INPUT
46   A10   INPUT
47   BA0   INPUT
48   A4   INPUT
49   VSS   GND
50   A6   INPUT
51   A0   INPUT
52   A8   INPUT
53   A2   INPUT
54   A11   INPUT
55   PARITY   INPUT
56   RESET_n   INPUT
57   VDD   POWER
58   VDD   POWER
59   VDD   POWER
60   VSS   GND
61   VSS   GND
62   VDD   POWER
63   VSSQ   GND
64   NC   NC
65   NC   NC
66   VDDQ   POWER
67   NC   NC
68   VSSQ   GND
69   VSS   GND
70   VDD   POWER
71   VDDQ   POWER
72   NC   NC
73   VSSQ   GND
74   NC   NC
75   VDDQ   POWER
76   NC   NC
77   VSSQ   GND
78   VDD   POWER
79   ZQ   INPUT
80   VDDQ   POWER
81   VSSQ   GND
82   DM_n_DBI_n_T   DM_DBI_TDQS
83   VDDQ   POWER
84   DQ1   DQ
85   VSSQ   GND
86   DQ3   DQ
87   VDDQ   POWER
88   DQ7   DQ
89   VSSQ   GND
90   DQ5   DQ
91   VDDQ   POWER
92   VDD   POWER
93   VDD   POWER
94   VSS   GND
95   VSS   GND
96   CK_t   CLKIN
97   CK_c   CLKIN
98   VSS   GND
99   CS_n   INPUT
100   RAS_n_A16   INPUT
101   CAS_n_A15   INPUT
102   BG1   INPUT
103   A12_BC_n   INPUT
104   BA1   INPUT
105   A3   INPUT
106   VDD   POWER
107   A5   INPUT
108   A1   INPUT
109   A7   INPUT
110   A9   INPUT
111   A13   INPUT
112   NC   NC
113   TEN   INPUT
114   ALERT_n   ALERT
115   VSS   GND
116   VSS   GND
117   VPP   POWER
118   VSS   GND
|**********************DIFF PIN*********************************************
[Diff_pin]   inv_pin   vdiff   tdelay_typ   tdelay_min   tdelay_max
   20   19   0.000V   0ns   NA   NA
   96   97   0.250V   0ns   NA   NA
| COMPONENT: MT40A512M16Z41C (Bare Die, x16)
[Component]   MT40A512M16Z41C
[Manufacturer]  Micron Technology,Inc.
[Package]
|   typ   min   max
R_pkg   0.001   0.001   0.001
L_pkg   0.001nH   0.001nH   0.001nH
C_pkg   0.001pF   0.001pF   0.001pF
[Pin]   signal_name   model_name   R_pin   L_pin   C_pin
1   VPP   POWER
2   VSS   GND
3   VDD   POWER
4   VDDQ   POWER
5   VSSQ   GND
6   DQ8   DQ
7   VDDQ   POWER
8   DQ10   DQ
9   VSSQ   GND
10   DQ12   DQ
11   VDDQ   POWER
12   DQ14   DQ
13   VSSQ   GND
14   UDM_n_UDBI_n   DM_DBI
15   VDDQ   POWER
16   VDD   POWER
17   VSS   GND
18   VSSQ   GND
19   LDQS_c   DQS
20   LDQS_t   DQS
21   VDDQ   POWER
22   DQ0   DQ
23   VSSQ   GND
24   VSS   GND
25   VDD   POWER
26   VDDQ   POWER
27   DQ2   DQ
28   VSSQ   GND
29   DQ6   DQ
30   VDDQ   POWER
31   DQ4   DQ
32   VSSQ   GND
33   VSS   GND
34   VDD   POWER
35   VSSDL   GND
36   VDDL   POWER
37   VDDL   POWER
38   VSSDL   GND
39   VDD   POWER
40   ODT   INPUT
41   CKE   INPUT
42   WE_n_A14   INPUT
43   ACT_n   INPUT
44   VREFCA   POWER
45   BG0   INPUT
46   A10   INPUT
47   BA0   INPUT
48   A4   INPUT
49   VSS   GND
50   A6   INPUT
51   A0   INPUT
52   A8   INPUT
53   A2   INPUT
54   A11   INPUT
55   PARITY   INPUT
56   RESET_n   INPUT
57   VDD   POWER
58   VDD   POWER
59   VDD   POWER
60   VSS   GND
61   VSS   GND
62   VDD   POWER
63   VSSQ   GND
64   UDQS_c   DQS
65   UDQS_t   DQS
66   VDDQ   POWER
67   DQ9   DQ
68   VSSQ   GND
69   VSS   GND
70   VDD   POWER
71   VDDQ   POWER
72   DQ11   DQ
73   VSSQ   GND
74   DQ13   DQ
75   VDDQ   POWER
76   DQ15   DQ
77   VSSQ   GND
78   VDD   POWER
79   ZQ   INPUT
80   VDDQ   POWER
81   VSSQ   GND
82   LDM_n_LDBI_n   DM_DBI
83   VDDQ   POWER
84   DQ1   DQ
85   VSSQ   GND
86   DQ3   DQ
87   VDDQ   POWER
88   DQ7   DQ
89   VSSQ   GND
90   DQ5   DQ
91   VDDQ   POWER
92   VDD   POWER
93   VDD   POWER
94   VSS   GND
95   VSS   GND
96   CK_t   CLKIN
97   CK_c   CLKIN
98   VSS   GND
99   CS_n   INPUT
100   RAS_n_A16   INPUT
101   CAS_n_A15   INPUT
102   NC   NC
103   A12_BC_n   INPUT
104   BA1   INPUT
105   A3   INPUT
106   VDD   POWER
107   A5   INPUT
108   A1   INPUT
109   A7   INPUT
110   A9   INPUT
111   A13   INPUT
112   NC   NC
113   TEN   INPUT
114   ALERT_n   ALERT
115   VSS   GND
116   VSS   GND
117   VPP   POWER
118   VSS   GND
|**********************DIFF PIN*********************************************
[Diff_pin]   inv_pin   vdiff   tdelay_typ   tdelay_min   tdelay_max
   20   19   0.000V   0ns   NA   NA
   65   64   0.000V   0ns   NA   NA
   96   97   0.250V   0ns   NA   NA
|   Model Selector
[Model Selector] DQ
DQ_34_3200   34 Ohm Data I/O with no ODT, 1600-3200Mbps
DQ_40_3200   40 Ohm Data I/O with no ODT, 1600-3200Mbps
DQ_48_3200   48 Ohm Data I/O with no ODT, 1600-3200Mbps
DQ_IN_ODTOFF_3200  Data Input with no ODT, 1600-3200Mbps
DQ_IN_ODT34_3200   Data Input with 34ohm ODT, 1600-3200Mbps
DQ_IN_ODT40_3200   Data Input with 40ohm ODT, 1600-3200Mbps
DQ_IN_ODT48_3200   Data Input with 48ohm ODT, 1600-3200Mbps
DQ_IN_ODT60_3200   Data Input with 60ohm ODT, 1600-3200Mbps
DQ_IN_ODT80_3200   Data Input with 80ohm ODT, 1600-3200Mbps
DQ_IN_ODT120_3200  Data Input with 120ohm ODT, 1600-3200Mbps
DQ_IN_ODT240_3200  Data Input with 240ohm ODT, 1600-3200Mbps
[Model Selector] DQS
DQS_34_3200   34 Ohm Data Strobe I/O with no ODT, 1600-3200Mbps
DQS_40_3200   40 Ohm Data Strobe I/O with no ODT, 1600-3200Mbps
DQS_48_3200   48 Ohm Data Strobe I/O with no ODT, 1600-3200Mbps
DQS_IN_ODTOFF_3200 Data Strobe Input with no ODT, 1600-3200Mbps
DQS_IN_ODT34_3200  Data Strobe Input with 34ohm ODT, 1600-3200Mbps
DQS_IN_ODT40_3200  Data Strobe Input with 40ohm ODT, 1600-3200Mbps
DQS_IN_ODT48_3200  Data Strobe Input with 48ohm ODT, 1600-3200Mbps
DQS_IN_ODT60_3200  Data Strobe Input with 60ohm ODT, 1600-3200Mbps
DQS_IN_ODT80_3200  Data Strobe Input with 80ohm ODT, 1600-3200Mbps
DQS_IN_ODT120_3200 Data Strobe Input with 120ohm ODT, 1600-3200Mbps
DQS_IN_ODT240_3200 Data Strobe Input with 240ohm ODT, 1600-3200Mbps
[Model Selector] DM_DBI
DM_ODTOFF_3200   DM Input Model with no ODT, 1600-3200Mbps
DM_ODT34_3200   DM Input Model with 34ohm ODT, 1600-3200Mbps
DM_ODT40_3200   DM Input Model with 40ohm ODT, 1600-3200Mbps
DM_ODT48_3200   DM Input Model with 48ohm ODT, 1600-3200Mbps
DM_ODT60_3200   DM Input Model with 60ohm ODT, 1600-3200Mbps
DM_ODT80_3200   DM Input Model with 80ohm ODT, 1600-3200Mbps
DM_ODT120_3200   DM Input Model with 120ohm ODT, 1600-3200Mbps
DM_ODT240_3200   DM Input Model with 240ohm ODT, 1600-3200Mbps
DQ_34_3200   34 Ohm DBI I/O with no ODT, 1600-3200Mbps
DQ_40_3200   40 Ohm DBI I/O with no ODT, 1600-3200Mbps
DQ_48_3200   48 Ohm DBI I/O with no ODT, 1600-3200Mbps
DQ_IN_ODTOFF_3200  DBI Input with no ODT, 1600-3200Mbps
DQ_IN_ODT34_3200   DBI Input with 34ohm ODT, 1600-3200Mbps
DQ_IN_ODT40_3200   DBI Input with 40ohm ODT, 1600-3200Mbps
DQ_IN_ODT48_3200   DBI Input with 48ohm ODT, 1600-3200Mbps
DQ_IN_ODT60_3200   DBI Input with 60ohm ODT, 1600-3200Mbps
DQ_IN_ODT80_3200   DBI Input with 80ohm ODT, 1600-3200Mbps
DQ_IN_ODT120_3200  DBI Input with 120ohm ODT, 1600-3200Mbps
DQ_IN_ODT240_3200  DBI Input with 240ohm ODT, 1600-3200Mbps
NF_DQ   Non-Functioning DQ Terminator Model
[Model Selector] DM_DBI_TDQS
DM_ODTOFF_3200   DM Input Model with no ODT, 1600-3200Mbps
DM_ODT34_3200   DM Input Model with 34ohm ODT, 1600-3200Mbps
DM_ODT40_3200   DM Input Model with 40ohm ODT, 1600-3200Mbps
DM_ODT48_3200   DM Input Model with 48ohm ODT, 1600-3200Mbps
DM_ODT60_3200   DM Input Model with 60ohm ODT, 1600-3200Mbps
DM_ODT80_3200   DM Input Model with 80ohm ODT, 1600-3200Mbps
DM_ODT120_3200   DM Input Model with 120ohm ODT, 1600-3200Mbps
DM_ODT240_3200   DM Input Model with 240ohm ODT, 1600-3200Mbps
TDQS_ODT34_3200   TDQS Terminator Model with 34ohm ODT, 1600-3200Mbps
TDQS_ODT40_3200   TDQS Terminator Model with 40ohm ODT, 1600-3200Mbps
TDQS_ODT48_3200   TDQS Terminator Model with 48ohm ODT, 1600-3200Mbps
TDQS_ODT60_3200   TDQS Terminator Model with 60ohm ODT, 1600-3200Mbps
TDQS_ODT80_3200   TDQS Terminator Model with 80ohm ODT, 1600-3200Mbps
TDQS_ODT120_3200   TDQS Terminator Model with 120ohm ODT, 1600-3200Mbps
TDQS_ODT240_3200   TDQS Terminator Model with 240ohm ODT, 1600-3200Mbps
NF_DQ   Non-Functioning DQ Terminator Model
[Model Selector] TDQS
TDQS_ODTOFF_3200   TDQS Terminator Model with no ODT, 1600-3200Mbps
TDQS_ODT34_3200   TDQS Terminator Model with 34ohm ODT, 1600-3200Mbps
TDQS_ODT40_3200   TDQS Terminator Model with 40ohm ODT, 1600-3200Mbps
TDQS_ODT48_3200   TDQS Terminator Model with 48ohm ODT, 1600-3200Mbps
TDQS_ODT60_3200   TDQS Terminator Model with 60ohm ODT, 1600-3200Mbps
TDQS_ODT80_3200   TDQS Terminator Model with 80ohm ODT, 1600-3200Mbps
TDQS_ODT120_3200   TDQS Terminator Model with 120ohm ODT, 1600-3200Mbps
TDQS_ODT240_3200   TDQS Terminator Model with 240ohm ODT, 1600-3200Mbps
NF_DQ   Non-Functioning DQ Terminator Model
| Sparse Matrix Package Model for z41c_78ball_pkg (x4/x8)
[Define Package Model]  z41c_78ball_pkg
[Manufacturer]   Micron Technology, Inc.
[OEM]   Micron Technology, Inc.
[Description]   z41c package model for 78-ball x4/x8 FBGA
[Number of Pins]   51
[Pin Numbers]
L3  | A0
L7  | A1
M3  | A2
K7  | A3
K3  | A4
L8  | A5
L2  | A6
M8  | A7
M2  | A8
M7  | A9
J3  | A10
N2  | A11
J7  | A12
N8  | A13
H3  | ACT_N
L9  | ALERT_N
K2  | BA0
K8  | BA1
J2  | BG0
J8  | BG1
H7  | CAS_N
G3  | CKE
F8  | CK_C
F7  | CK_T
G7  | CS_N
F3  | ODT
N3  | PAR
H8  | RAS_N
L1  | RESET_N
H2  | WE_N
C2  | DQ0
D3  | DQ2
D2  | DQ4
E3  | DQ6
B3  | DQS_C
C3  | DQS_T
A3  | TDQS_C
A7  | DM_N
B7  | DQ1
D7  | DQ3
D8  | DQ5
E7  | DQ7
G9  | TEN
A1  | VDD
B2  | VDDQ_SUBNET_0
B8  | VDDQ_SUBNET_1
B1  | VPP_B1
M9  | VPP_M9
J1  | VREFCA
A9  | VSS
B9  | ZQ
[Model Data]
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[End Model Data]
[End Package Model]
| Sparse Matrix Package Model for z41c_96ball_pkg (x16)
[Define Package Model]  z41c_96ball_pkg
[Manufacturer]   Micron Technology, Inc.
[OEM]   Micron Technology, Inc.
[Description]   z21c package model for 96-ball x16 FBGA
[Number of Pins]   61
[Pin Numbers]
P3  | A0
P7  | A1
R3  | A2
N7  | A3
N3  | A4
P8  | A5
P2  | A6
R8  | A7
R2  | A8
R7  | A9
M3  | A10
T2  | A11
M7  | A12
T8  | A13
L3  | ACT_N
P9  | ALERT_N
N2  | BA0
N8  | BA1
M2  | BG0
M8  | CAS_N
K2  | CKE
K8  | CK_C
K7  | CK_T
L7  | CS_N
K3  | ODT
T3  | PAR
L8  | RAS_N
P1  | RESET_N
L2  | WE_N
G2  | DQ0
F7  | DQ1
H3  | DQ2
H7  | DQ3
H2  | DQ4
H8  | DQ5
J3  | DQ6
J7  | DQ7
A3  | DQ8
B8  | DQ9
C3  | DQ10
C7  | DQ11
C2  | DQ12
C8  | DQ13
D3  | DQ14
D7  | DQ15
E7  | LDM_N
F3  | LDQS_C
G3  | LDQS_T
E2  | UDM_N
A7  | UDQS_C
B7  | UDQS_T
F9  | ZQ
N9  | TEN
B3  | VDD
J1  | VDDL
A9  | VDDQ_SUBNET_0
J8  | VDDQ_SUBNET_1
B1  | VPP_B1
R9  | VPP_R9
M1  | VREFCA
B2  | VSS
[Model Data]
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[End Model Data]
[End Package Model]
| Models and submodels in the file (49): DQ_34_3200 (I/O), DQ_40_3200 (I/O), DQ_48_3200 (I/O), DQ_IN_ODTOFF_3200 (Input), DQ_IN_ODT34_3200 (Input), DQ_IN_ODT40_3200 (Input), DQ_IN_ODT48_3200 (Input), DQ_IN_ODT60_3200 (Input), DQ_IN_ODT80_3200 (Input), DQ_IN_ODT120_3200 (Input), DQ_IN_ODT240_3200 (Input), DQS_34_3200 (I/O), DQS_40_3200 (I/O), DQS_48_3200 (I/O), DQS_IN_ODTOFF_3200 (Input), DQS_IN_ODT34_3200 (Input), DQS_IN_ODT40_3200 (Input), DQS_IN_ODT48_3200 (Input), DQS_IN_ODT60_3200 (Input), DQS_IN_ODT80_3200 (Input), DQS_IN_ODT120_3200 (Input), DQS_IN_ODT240_3200 (Input), DM_ODTOFF_3200 (Input), DM_ODT34_3200 (Input), DM_ODT40_3200 (Input), DM_ODT48_3200 (Input), DM_ODT60_3200 (Input), DM_ODT80_3200 (Input), DM_ODT120_3200 (Input), DM_ODT240_3200 (Input), TDQS_ODTOFF_3200 (Terminator), TDQS_ODT34_3200 (Terminator), TDQS_ODT40_3200 (Terminator), TDQS_ODT48_3200 (Terminator), TDQS_ODT60_3200 (Terminator), TDQS_ODT80_3200 (Terminator), TDQS_ODT120_3200 (Terminator), TDQS_ODT240_3200 (Terminator), INPUT (Input), CLKIN (Input), ALERT (Open_sink), NF_DQ (Terminator), 34ohm_ODT_3200 (Dynamic_clamp), 40ohm_ODT_3200 (Dynamic_clamp), 48ohm_ODT_3200 (Dynamic_clamp), 60ohm_ODT_3200 (Dynamic_clamp), 80ohm_ODT_3200 (Dynamic_clamp), 120ohm_ODT_3200 (Dynamic_clamp), 240ohm_ODT_3200 (Dynamic_clamp)
