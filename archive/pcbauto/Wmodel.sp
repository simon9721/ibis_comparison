*Wmodel Definition*
*TraceModel Definition*
.Model Wmodel_Trace01::Sig W MODELTYPE=RLGC N=1
+ Lo=
+ 6.55731159e-07
+ Co=
+ 4.37013845e-11
+ Ro=
+ 4.84853186e+00
+ Go=
+ 0.00000000e+00
+ Rs=
+ 1.26077349e-03
+ Gd=
+ 0.00000000e+00

.Model Wmodel_Trace02::Sig W MODELTYPE=RLGC N=1
+ Lo=
+ 6.55731159e-07
+ Co=
+ 4.37013845e-11
+ Ro=
+ 4.84853186e+00
+ Go=
+ 0.00000000e+00
+ Rs=
+ 1.26077349e-03
+ Gd=
+ 0.00000000e+00

.Model Wmodel_Trace03::Sig W MODELTYPE=RLGC N=1
+ Lo=
+ 3.61203392e-07
+ Co=
+ 8.30361947e-11
+ Ro=
+ 4.84853186e+00
+ Go=
+ 0.00000000e+00
+ Rs=
+ 1.71539844e-03
+ Gd=
+ 0.00000000e+00
