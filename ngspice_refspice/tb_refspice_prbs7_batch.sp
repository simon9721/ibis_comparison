* ============================================================
* PRBS7 eye diagram bench — transistor-level reference SPICE
* 200 Mbps (5 ns UI), 200 bits = 1000 ns
* ============================================================

.temp 27
.options method=gear maxord=2 reltol=1e-3 abstol=1e-9 vntol=1e-5 gmin=1e-10 trtol=10

* V-source PWL: ngspice queues breakpoints as timestep events (fast)
* Generated by scripts/gen_prbs7.py
.include 'prbs7_vstim.inc'
Rin    in_src  in_dig  1

Vdd_ref  vdd_ref_src  0  DC 3.3
Voe_ref  oe_ref_src   0  DC 3.3
Rvdd_ref vdd_ref_src  vdd_ref  1
Roe_ref  oe_ref_src   oe_ref   1
Cdec_ref vdd_ref      0        10p

.subckt SPICE_BUF in oe out in_sense vdd vss
.include '../hspice_ngspice.mod'
.include '../io_buf.sp'
.ends SPICE_BUF

XREF in_dig oe_ref pad_ref in_sense_ref vdd_ref 0 SPICE_BUF

T1  pad_ref  0  ntst_ref  0  Z0=50 Td=30p
R1  ntst_ref 0  50

.save V(in_dig) V(pad_ref) V(ntst_ref) V(in_sense_ref)
* uic: skip DCOP. With in=3.3V at t=0, pfet is ON but T-line has no DC return
* path, so DCOP gives wrong 1.52V midpoint -> immediate timestep collapse.
* Start from 0V on all nodes; circuit reaches steady state within first UI.
.ic V(pad_ref)=0 V(ntst_ref)=0
.tran 10p 1000n uic

.end
