* On-die Decoupling circuit for z41c (VDDQ to VSSQ)
* Includes VDDQ-VSSQ decoupling for an individual signal such as DQ0-15, LDQS_t/c, UDQS_t/c, UDM or LDM.
* This subcircuit should be added across the IBIS DQ, DM or DQS model's [Pullup Reference] and [Pulldown Reference]
* nodes as in the following Spice example:

******************************************************************************************************
*x_decouple vddq_die vssq_die gnd z41c_ondie_decoupling_perdq

*b_dq1 vccq_die vssq_die PAD_DQ1 IN_DQ1 ENOUT RCVR_OUT_DQ1 vccq_die vssq_die
*+ file='z41c.ibs' model='DQ_40_3200' typ=typ power=off buffer=3 interpol=1 ramp_fwf=2 ramp_rwf=2
*+ rm_tail_rwf=default rm_tail_fwf=default
*+ rm_dly_rwf=default rm_dly_fwf=default
******************************************************************************************************

.subckt z41c_ondie_decoupling_perdq vddq_die vssq_die ref
x1 vddq_die vssq_die ref z41c_cfat_perdq

**********************************************************
** STATE-SPACE REALIZATION
** IN SPICE LANGUAGE
** This file is automatically generated
**********************************************************
** Created: 13-Apr-2020 by IdEM MP 12 (12.1.0)
**********************************************************
**
**********************************************************
** COMMENTS
**********************************************************
**
**  NPort=2 DATA=1332 NOISE=0 GROUPDELAY=0 COMPLEX_DATAFORMAT=POLAR
**  NumOfBlock=1 NumOfParam=0
**
**  .MODEL Smodel S TSTONEFILE=cfat_perdq_sparam_50.s2p TYPE=S
**    -- The above .MODEL line can be used for the S element in the netlist.
**
**
**
**********************************************************
**
**
**---------------------------
** Options Used in IdEM Flow
**---------------------------
**
** Fitting Options **
**
** Bandwidth: 2.0417e+10 Hz
** Order: [2 2 6]
** SplitType: none
** tol: 1.0000e-04
**
**---------------------------
**
** Passivity Options **
**
** Alg: SOC+HAM
**    Max SOC it: 50
**    Max HAM it: 50
** Freq sampling: manual
**    In-band samples: 200
**    Off-band samples: 100
** Optimization method: Model based
**
**---------------------------
**
** Netlist Options **
**
** Netlist format: SPICE standard
** Port reference: common
** Resistor synthesis: standard
**
**---------------------------
**
**********************************************************
* NOTE:
* a_i  --> input node associated to the port i
* ref  --> reference node, common for all the input nodes
**********************************************************

***********************************
* Interface (ports specification) *
***********************************
.subckt z41c_cfat_perdq
+  a_1 a_2 ref
***********************************

******************************************
* Main circuit connected to output nodes *
******************************************

* Port 1
VI_1 a_1 NI_1 0
RI_1 NI_1 ref 5.0000000000000000e+01
GC_1_1 ref NI_1 NS_1 0 1.8307860148483290e-03
GC_1_2 ref NI_1 NS_2 0 1.8617473116028889e-03
GC_1_3 ref NI_1 NS_3 0 3.1978633500681281e-03
GC_1_4 ref NI_1 NS_4 0 2.5962187987731616e-02
GC_1_5 ref NI_1 NS_5 0 1.6258450562822021e-06
GC_1_6 ref NI_1 NS_6 0 3.7771503995352566e-04
GC_1_7 ref NI_1 NS_7 0 -1.8307859798248692e-03
GC_1_8 ref NI_1 NS_8 0 -1.8617473194690001e-03
GC_1_9 ref NI_1 NS_9 0 -3.1978633492571289e-03
GC_1_10 ref NI_1 NS_10 0 -2.5962187986199026e-02
GC_1_11 ref NI_1 NS_11 0 -1.6258450485791684e-06
GC_1_12 ref NI_1 NS_12 0 -3.7771504005042542e-04
GD_1_1 ref NI_1 NA_1 0 3.4534465566322149e-03
GD_1_2 ref NI_1 NA_2 0 2.7938926589245960e-01
*
* Port 2
VI_2 a_2 NI_2 0
RI_2 NI_2 ref 5.0000000000000000e+01
GC_2_1 ref NI_2 NS_1 0 -1.8307859941602961e-03
GC_2_2 ref NI_2 NS_2 0 -1.8617473157254590e-03
GC_2_3 ref NI_2 NS_3 0 -3.1978633492491470e-03
GC_2_4 ref NI_2 NS_4 0 -2.5962187986184552e-02
GC_2_5 ref NI_2 NS_5 0 -1.6258450484962369e-06
GC_2_6 ref NI_2 NS_6 0 -3.7771504005120246e-04
GC_2_7 ref NI_2 NS_7 0 1.8307860216262932e-03
GC_2_8 ref NI_2 NS_8 0 1.8617473059258528e-03
GC_2_9 ref NI_2 NS_9 0 3.1978633515425455e-03
GC_2_10 ref NI_2 NS_10 0 2.5962187984147483e-02
GC_2_11 ref NI_2 NS_11 0 1.6258450400381172e-06
GC_2_12 ref NI_2 NS_12 0 3.7771504009703012e-04
GD_2_1 ref NI_2 NA_1 0 2.7938926589184854e-01
GD_2_2 ref NI_2 NA_2 0 3.4534465568385351e-03
*
******************************************

********************************
* Synthesis of impinging waves *
********************************

* Impinging wave, port 1
RA_1 NA_1 0 3.5355339059327378e+00
FA_1 0 NA_1 VI_1 1.0
GA_1 0 NA_1 a_1 ref 2.0000000000000000e-02
*
* Impinging wave, port 2
RA_2 NA_2 0 3.5355339059327378e+00
FA_2 0 NA_2 VI_2 1.0
GA_2 0 NA_2 a_2 ref 2.0000000000000000e-02
*
********************************

***************************************
* Synthesis of real and complex poles *
***************************************

* Real pole n. 1
CS_1 NS_1 0 1.0000000000000001e-09
RS_1 NS_1 0 2.6001637424213325e-01
GS_1_1 0 NS_1 NA_1 0 1.8358039180017985e-01
*
* Real pole n. 2
CS_2 NS_2 0 1.0000000000000001e-09
RS_2 NS_2 0 1.6334847507254857e+00
GS_2_1 0 NS_2 NA_1 0 1.8358039180017985e-01
*
* Real pole n. 3
CS_3 NS_3 0 1.0000000000000001e-09
RS_3 NS_3 0 1.4844367987197325e+01
GS_3_1 0 NS_3 NA_1 0 1.8358039180017985e-01
*
* Real pole n. 4
CS_4 NS_4 0 1.0000000000000001e-09
RS_4 NS_4 0 5.4096496244725110e+01
GS_4_1 0 NS_4 NA_1 0 1.8358039180017985e-01
*
* Real pole n. 5
CS_5 NS_5 0 1.0000000000000001e-09
RS_5 NS_5 0 1.9963464253616849e+03
GS_5_1 0 NS_5 NA_1 0 1.8358039180017985e-01
*
* Real pole n. 6
CS_6 NS_6 0 1.0000000000000001e-09
RS_6 NS_6 0 1.6723565125204934e+02
GS_6_1 0 NS_6 NA_1 0 1.8358039180017985e-01
*
* Real pole n. 7
CS_7 NS_7 0 1.0000000000000001e-09
RS_7 NS_7 0 2.6001637424213325e-01
GS_7_2 0 NS_7 NA_2 0 1.8358039180017985e-01
*
* Real pole n. 8
CS_8 NS_8 0 1.0000000000000001e-09
RS_8 NS_8 0 1.6334847507254857e+00
GS_8_2 0 NS_8 NA_2 0 1.8358039180017985e-01
*
* Real pole n. 9
CS_9 NS_9 0 1.0000000000000001e-09
RS_9 NS_9 0 1.4844367987197325e+01
GS_9_2 0 NS_9 NA_2 0 1.8358039180017985e-01
*
* Real pole n. 10
CS_10 NS_10 0 1.0000000000000001e-09
RS_10 NS_10 0 5.4096496244725110e+01
GS_10_2 0 NS_10 NA_2 0 1.8358039180017985e-01
*
* Real pole n. 11
CS_11 NS_11 0 1.0000000000000001e-09
RS_11 NS_11 0 1.9963464253616849e+03
GS_11_2 0 NS_11 NA_2 0 1.8358039180017985e-01
*
* Real pole n. 12
CS_12 NS_12 0 1.0000000000000001e-09
RS_12 NS_12 0 1.6723565125204934e+02
GS_12_2 0 NS_12 NA_2 0 1.8358039180017985e-01
*
******************************

.ends
.ends
*******************
* End of subcircuit
*******************
