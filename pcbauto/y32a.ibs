| y32a.ibs * IBIS 5.0 Model
| 16Gb DDR5 SDRAM - Die Revision "A"
| This Model is valid for Commercial Temperature Range 0C<=Tc<=95C
| Valid for up to 4800 Gbps DDR5 operation
| Part Number   VDD/VDDQ   Architecture   Package
| MT60B4G4HB   1.1V/1.1V   4Gb   x 4   78-Ball VFBGA
| MT60B2G8HB   1.1V/1.1V   2Gb   x 8   78-Ball VFBGA
| MT60B1G16HC   1.1V/1.1V   1Gb   x 16   102-Ball VFBGA
[IBIS Ver]   5.0
[File Name]   y32a.ibs
[Date]   4/21/2021
[File Rev]   2.2
[Source]   From silicon level SPICE model at Micron Technology, Inc.
   For support contact your local Micron FAE/Sales contacts
   (more information at https://www.micron.com/support/sales-network)
[Notes]   Revision History:
   Rev 2.2: 4/21/2021
   - Matched C_comp with 4/13/2020 measurements
   - Updated CA, CLK and CS models with specific (per ODT)
   C_comp values
   Rev 2.1: 1/8/2021
   - Matched C_comp with 7/28/2020 measurements
   Rev 2.0.2: 12/14/2020
   - Reordered TDQS and DM_TDQS selectors to have *ODT_OFF* the
   first (default) model
   Rev 2.0.1: 9/9/2020
   - Updated Sparse Matrix package models for bith x8 and x16
   Rev 2.0: 7/14/2020
   - Matched C_comp with 4/6/2020 measurements
   - Matched IV curves with 3/18/2020 measurements
   - Renamed INPUT* models to CA_INPUT*
   - Renamed CLKIN* models to CLK_INPUT*
   - Added CS_INPUT* models
   Rev 1.1: 10/30/2019
   - Added component MT60B1G16HC (x16)
   - Updated part numbers MT60B4G4HB (x4) and MT60B2G8HB (x8)
   Rev 1.0: 6/14/2019
   - Added INPUT_ODT240_4800 and CLKIN_ODT240_4800 models
   - Updated VT tables for DQ model family
   - Updated ALERT model
   - Updated part numbers
   Rev 0.1: 6/10/2019
   - Initial release
   Notes:
   - This IBIS file uses the Submodel keyword to model the
   DDR5 On-die Termination(ODT) characteristics.
   - The C_comp value in the DQ I/O model is set to match the
   input state of the DQ I/O as measured from the HSPICE model.
   The C_comp value decreases in the DQ/DQS Input ODT models.
   - L_pin values in the Pin sections are loop inductance and
   include the mutual inductance to appropriate POWER/GND
   return paths.  POWER/GND parasitics are modeled in the
   Package Models.
   - Typ and slow corner V-t curves in the following DQ* models
   are shifted relative to strong corner V-t curve
   to contain all 3 corners within appropriate V-t window
   Models   Typ   Slow   V-t duration
   DQ_*_4800   -100ps   -255ps   300ps
   ALERT   -67ps   -175ps   300ps
   - Due to the shift in typ and slow corner, the V-t curves
   may overlap each other. This does not effect the accuracy
   of the IBIS data.
   - DBI is not supported yet for y32a
   - The NF_DQ Model is for Non-functioning pins in the x4
   package
   - IBIS Quality Specification 2.0 Summary:
   IQ Score: IQ3MSX
   See Micron IBIS Model Quality Report and Quality Checklist
   for full IQ details
[Disclaimer]  This software code and all associated documentation, comments
              or other information (collectively "Software") is provided
              "AS IS" without warranty of any kind. MICRON TECHNOLOGY, INC.
              ("MTI") EXPRESSLY DISCLAIMS ALL WARRANTIES EXPRESS OR IMPLIED,
              INCLUDING BUT NOT LIMITED TO, NONINFRINGEMENT OF THIRD PARTY
              RIGHTS, AND ANY IMPLIED WARRANTIES OF MERCHANTABILITY OR
              FITNESS FOR ANY PARTICULAR PURPOSE. MTI DOES NOT WARRANT THAT
              THE SOFTWARE WILL MEET YOUR REQUIREMENTS, OR THAT THE
              OPERATION OF THE SOFTWARE WILL BE UNINTERRUPTED OR ERROR-FREE.
              FURTHERMORE, MTI DOES NOT MAKE ANY REPRESENTATIONS REGARDING
              THE USE OR THE RESULTS OF THE USE OF THE SOFTWARE IN TERMS OF
              ITS CORRECTNESS, ACCURACY, RELIABILITY, OR OTHERWISE. THE
              ENTIRE RISK ARISING OUT OF USE OR PERFORMANCE OF THE SOFTWARE
              REMAINS WITH YOU. IN NO EVENT SHALL MTI, ITS AFFILIATED
              COMPANIES OR THEIR SUPPLIERS BE LIABLE FOR ANY DIRECT,
              INDIRECT, CONSEQUENTIAL, INCIDENTAL, OR SPECIAL DAMAGES
              (INCLUDING, WITHOUT LIMITATION, DAMAGES FOR LOSS OF PROFITS,
              BUSINESS INTERRUPTION, OR LOSS OF INFORMATION) ARISING OUT OF
              YOUR USE OF OR INABILITY TO USE THE SOFTWARE, EVEN IF MTI HAS
              BEEN ADVISED OF THE POSSIBILITY OF SUCH DAMAGES. Because some
              jurisdictions prohibit the exclusion or limitation of
              liability for consequential or incidental damages, the above
              limitation may not apply to you.
[Copyright]   Copyright 2021 Micron Technology, Inc. All rights reserved.
| COMPONENT: MT60B4G4HB (78-Ball FBGA, x4)
[Component]   MT60B4G4HB
[Package Model] y32a_78ball_pkg
[Manufacturer]  Micron Technology,Inc.
[Package]
|   typ   min   max
R_pkg   0.634   0.357   1.071
L_pkg   1.858nH   1.005nH   3.405nH
C_pkg   0.435pF   0.260pF   0.863pF
[Pin]   signal_name   model_name   R_pin   L_pin   C_pin   | TD_pin(ps)   Z_pin
A1   LBDQ   LBDQ   0.745   1.797nH   0.444pF   | 28.247   63.612
A2   VSS   GND
A3   VPP   POWER
A7   ZQ   NC
A8   VSS   GND
A9   LBDQS   LBDQ   0.732   1.788nH   0.438pF   | 27.977   63.909
B1   VDD   POWER
B2   VDDQ   POWER
B3   DQ2   DQ   0.801   1.913nH   0.484pF   | 30.432   62.871
B7   DQ3   DQ   0.801   1.883nH   0.481pF   | 30.084   62.600
B8   VDDQ   POWER
B9   VDD   POWER
C1   VSS   GND
C2   DQ0   DQ   0.809   1.844nH   0.488pF   | 29.999   61.473
C3   DQS_t   DQS   0.792   2.181nH   0.509pF   | 33.315   65.472
C7   NF   NF_DQ   0.810   2.216nH   0.520pF   | 33.948   65.283
C8   DQ1   DQ   0.808   1.863nH   0.488pF   | 30.152   61.776
C9   VSS   GND
D1   VDDQ   POWER
D2   VSS   GND
D3   DQS_c   DQS   0.791   2.170nH   0.499pF   | 32.911   65.947
D7   NF   NF_DQ   0.809   2.213nH   0.511pF   | 33.614   65.826
D8   VSS   GND
D9   VDDQ   POWER
E1   VDD   POWER
E2   DQ4   NC
E3   DQ6   NC
E7   DQ7   NC
E8   DQ5   NC
E9   VDD   POWER
F1   VSS   GND
F2   VDDQ   POWER
F3   VSS   GND
F7   VSS   GND
F8   VDDQ   POWER
F9   VSS   GND
G1   CA_ODT   CTRL   0.724   1.860nH   0.464pF   | 29.381   63.307
G2   MIR   CTRL   1.246   3.389nH   0.902pF   | 55.297   61.286
G3   VDD   POWER
G7   CK_t   CLK_INPUT   0.486   1.290nH   0.293pF   | 19.450   66.332
G8   VDDQ   POWER
G9   TEN   CTRL   1.204   3.352nH   0.874pF   | 54.135   61.924
H1   ALERT_n   ALERT   0.721   1.914nH   0.431pF   | 28.721   66.637
H2   VSS   GND
H3   CS_n   CS_INPUT   0.418   1.001nH   0.267pF   | 16.338   61.264
H7   CK_c   CLK_INPUT   0.488   1.280nH   0.292pF   | 19.346   66.142
H8   VSSDL   GND
H9   VDDL   POWER
J1   VDDQ   POWER
J2   CA4   CA_INPUT   0.651   1.507nH   0.377pF   | 23.839   63.230
J3   CA0   CA_INPUT   0.651   1.462nH   0.379pF   | 23.545   62.082
J7   CA1   CA_INPUT   0.651   1.485nH   0.379pF   | 23.732   62.583
J8   CA5   CA_INPUT   0.657   1.556nH   0.378pF   | 24.268   64.130
J9   VDDQ   POWER
K1   VDD   POWER
K2   CA6   CA_INPUT   0.651   1.512nH   0.387pF   | 24.188   62.490
K3   CA2   CA_INPUT   0.662   1.691nH   0.368pF   | 24.937   67.828
K7   CA3   CA_INPUT   0.653   1.671nH   0.351pF   | 24.227   68.957
K8   CA7   CA_INPUT   0.659   1.530nH   0.387pF   | 24.335   62.857
K9   VDD   POWER
L1   VDDQ   POWER
L2   VSS   GND
L3   CA8   CA_INPUT   0.661   1.554nH   0.407pF   | 25.135   61.827
L7   CA9   CA_INPUT   0.653   1.562nH   0.403pF   | 25.105   62.225
L8   VSS   GND
L9   VDDQ   POWER
M1   CAI   CTRL   0.945   2.413nH   0.710pF   | 41.390   58.313
M2   CA10   CA_INPUT   0.670   1.592nH   0.405pF   | 25.399   62.674
M3   CA12   CA_INPUT   0.673   1.606nH   0.425pF   | 26.138   61.458
M7   CA13   CA_INPUT   0.675   1.660nH   0.398pF   | 25.697   64.591
M8   CA11   CA_INPUT   0.676   1.608nH   0.409pF   | 25.638   62.731
M9   RESET_n   CTRL   0.965   2.578nH   0.707pF   | 42.708   60.367
N1   VDD   POWER
N2   VSS   GND
N3   VDD   POWER
N7   VPP   POWER
N8   VSS   GND
N9   VDD   POWER
|***********************PIN MAPPING*****************************************
[Pin Mapping]   pulldown_ref   pullup_ref   gnd_clamp_ref   power_clamp_ref  ext_ref
A1   VSS   VDDQ   VSS   VDDQ
A2   VSS   NC
A3   NC   VPP
A7   NC   NC
A8   VSS   NC
A9   VSS   VDDQ   VSS   VDDQ
B1   NC   VDD
B2   NC   VDDQ
B3   VSS   VDDQ   VSS   VDDQ
B7   VSS   VDDQ   VSS   VDDQ
B8   NC   VDDQ
B9   NC   VDD
C1   VSS   NC
C2   VSS   VDDQ   VSS   VDDQ
C3   VSS   VDDQ   VSS   VDDQ
C7   NC   NC   VSS   VDDQ
C8   VSS   VDDQ   VSS   VDDQ
C9   VSS   NC
D1   NC   VDDQ
D2   VSS   NC
D3   VSS   VDDQ   VSS   VDDQ
D7   NC   NC   VSS   VDDQ
D8   VSS   NC
D9   NC   VDDQ
E1   NC   VDD
E2   NC   NC
E3   NC   NC
E7   NC   NC
E8   NC   NC
E9   NC   VDD
F1   VSS   NC
F2   NC   VDDQ
F3   VSS   NC
F7   VSS   NC
F8   NC   VDDQ
F9   VSS   NC
G1   NC   NC   VSS   VDDQ
G2   NC   NC   VSS   VDDQ
G3   NC   VDD
G7   NC   VDDQ   VSS   VDDQ
G8   NC   VDDQ
G9   NC   NC   VSS   VDDQ
H1   VSS   VDDQ   VSS   VDDQ
H2   VSS   NC
H3   NC   VDDQ   VSS   VDDQ
H7   NC   VDDQ   VSS   VDDQ
H8   VSS   NC
H9   NC   VDD
J1   NC   VDDQ
J2   NC   VDDQ   VSS   VDDQ
J3   NC   VDDQ   VSS   VDDQ
J7   NC   VDDQ   VSS   VDDQ
J8   NC   VDDQ   VSS   VDDQ
J9   NC   VDDQ
K1   NC   VDD
K2   NC   VDDQ   VSS   VDDQ
K3   NC   VDDQ   VSS   VDDQ
K7   NC   VDDQ   VSS   VDDQ
K8   NC   VDDQ   VSS   VDDQ
K9   NC   VDD
L1   NC   VDDQ
L2   VSS   NC
L3   NC   VDDQ   VSS   VDDQ
L7   NC   VDDQ   VSS   VDDQ
L8   VSS   NC
L9   NC   VDDQ
M1   NC   NC   VSS   VDDQ
M2   NC   VDDQ   VSS   VDDQ
M3   NC   VDDQ   VSS   VDDQ
M7   NC   VDDQ   VSS   VDDQ
M8   NC   VDDQ   VSS   VDDQ
M9   NC   NC   VSS   VDDQ
N1   NC   VDD
N2   VSS   NC
N3   NC   VDD
N7   NC   VPP
N8   VSS   NC
N9   NC   VDD
|**********************DIFF PIN*********************************************
[Diff_pin]   inv_pin   vdiff   tdelay_typ   tdelay_min   tdelay_max
   C3   D3   0.150V   0ns   NA   NA
   G7   H7   0.150V   0ns   NA   NA
| COMPONENT: MT60B2G8HB (78-Ball FBGA, x8)
[Component]   MT60B2G8HB
[Package Model] y32a_78ball_pkg
[Manufacturer]  Micron Technology,Inc.
[Package]
|   typ   min   max
R_pkg   0.634   0.357   1.071
L_pkg   1.858nH   1.005nH   3.405nH
C_pkg   0.435pF   0.260pF   0.863pF
[Pin]   signal_name   model_name   R_pin   L_pin   C_pin   | TD_pin(ps)   Z_pin
A1   LBDQ   LBDQ   0.745   1.797nH   0.444pF   | 28.247   63.612
A2   VSS   GND
A3   VPP   POWER
A7   ZQ   NC
A8   VSS   GND
A9   LBDQS   LBDQ   0.732   1.788nH   0.438pF   | 27.977   63.909
B1   VDD   POWER
B2   VDDQ   POWER
B3   DQ2   DQ   0.801   1.913nH   0.484pF   | 30.432   62.871
B7   DQ3   DQ   0.801   1.883nH   0.481pF   | 30.084   62.600
B8   VDDQ   POWER
B9   VDD   POWER
C1   VSS   GND
C2   DQ0   DQ   0.809   1.844nH   0.488pF   | 29.999   61.473
C3   DQS_t   DQS   0.792   2.181nH   0.509pF   | 33.315   65.472
C7   DM_n_TDQS_t   DM_TDQS   0.810   2.216nH   0.520pF   | 33.948   65.283
C8   DQ1   DQ   0.808   1.863nH   0.488pF   | 30.152   61.776
C9   VSS   GND
D1   VDDQ   POWER
D2   VSS   GND
D3   DQS_c   DQS   0.791   2.170nH   0.499pF   | 32.911   65.947
D7   TDQS_c   TDQS   0.809   2.213nH   0.511pF   | 33.614   65.826
D8   VSS   GND
D9   VDDQ   POWER
E1   VDD   POWER
E2   DQ4   DQ   0.796   1.920nH   0.476pF   | 30.221   63.541
E3   DQ6   DQ   0.789   1.900nH   0.435pF   | 28.737   66.118
E7   DQ7   DQ   0.791   1.931nH   0.431pF   | 28.857   66.900
E8   DQ5   DQ   0.807   1.937nH   0.482pF   | 30.557   63.396
E9   VDD   POWER
F1   VSS   GND
F2   VDDQ   POWER
F3   VSS   GND
F7   VSS   GND
F8   VDDQ   POWER
F9   VSS   GND
G1   CA_ODT   CTRL   0.724   1.860nH   0.464pF   | 29.381   63.307
G2   MIR   CTRL   1.246   3.389nH   0.902pF   | 55.297   61.286
G3   VDD   POWER
G7   CK_t   CLK_INPUT   0.486   1.290nH   0.293pF   | 19.450   66.332
G8   VDDQ   POWER
G9   TEN   CTRL   1.204   3.352nH   0.874pF   | 54.135   61.924
H1   ALERT_n   ALERT   0.721   1.914nH   0.431pF   | 28.721   66.637
H2   VSS   GND
H3   CS_n   CS_INPUT   0.418   1.001nH   0.267pF   | 16.338   61.264
H7   CK_c   CLK_INPUT   0.488   1.280nH   0.292pF   | 19.346   66.142
H8   VSSDL   GND
H9   VDDL   POWER
J1   VDDQ   POWER
J2   CA4   CA_INPUT   0.651   1.507nH   0.377pF   | 23.839   63.230
J3   CA0   CA_INPUT   0.651   1.462nH   0.379pF   | 23.545   62.082
J7   CA1   CA_INPUT   0.651   1.485nH   0.379pF   | 23.732   62.583
J8   CA5   CA_INPUT   0.657   1.556nH   0.378pF   | 24.268   64.130
J9   VDDQ   POWER
K1   VDD   POWER
K2   CA6   CA_INPUT   0.651   1.512nH   0.387pF   | 24.188   62.490
K3   CA2   CA_INPUT   0.662   1.691nH   0.368pF   | 24.937   67.828
K7   CA3   CA_INPUT   0.653   1.671nH   0.351pF   | 24.227   68.957
K8   CA7   CA_INPUT   0.659   1.530nH   0.387pF   | 24.335   62.857
K9   VDD   POWER
L1   VDDQ   POWER
L2   VSS   GND
L3   CA8   CA_INPUT   0.661   1.554nH   0.407pF   | 25.135   61.827
L7   CA9   CA_INPUT   0.653   1.562nH   0.403pF   | 25.105   62.225
L8   VSS   GND
L9   VDDQ   POWER
M1   CAI   CTRL   0.945   2.413nH   0.710pF   | 41.390   58.313
M2   CA10   CA_INPUT   0.670   1.592nH   0.405pF   | 25.399   62.674
M3   CA12   CA_INPUT   0.673   1.606nH   0.425pF   | 26.138   61.458
M7   CA13   CA_INPUT   0.675   1.660nH   0.398pF   | 25.697   64.591
M8   CA11   CA_INPUT   0.676   1.608nH   0.409pF   | 25.638   62.731
M9   RESET_n   CTRL   0.965   2.578nH   0.707pF   | 42.708   60.367
N1   VDD   POWER
N2   VSS   GND
N3   VDD   POWER
N7   VPP   POWER
N8   VSS   GND
N9   VDD   POWER
|***********************PIN MAPPING*****************************************
[Pin Mapping]   pulldown_ref   pullup_ref   gnd_clamp_ref   power_clamp_ref  ext_ref
A1   VSS   VDDQ   VSS   VDDQ
A2   VSS   NC
A3   NC   VPP
A7   NC   NC
A8   VSS   NC
A9   VSS   VDDQ   VSS   VDDQ
B1   NC   VDD
B2   NC   VDDQ
B3   VSS   VDDQ   VSS   VDDQ
B7   VSS   VDDQ   VSS   VDDQ
B8   NC   VDDQ
B9   NC   VDD
C1   VSS   NC
C2   VSS   VDDQ   VSS   VDDQ
C3   VSS   VDDQ   VSS   VDDQ
C7   NC   NC   VSS   VDDQ
C8   VSS   VDDQ   VSS   VDDQ
C9   VSS   NC
D1   NC   VDDQ
D2   VSS   NC
D3   VSS   VDDQ   VSS   VDDQ
D7   NC   NC   VSS   VDDQ
D8   VSS   NC
D9   NC   VDDQ
E1   NC   VDD
E2   VSS   VDDQ   VSS   VDDQ
E3   VSS   VDDQ   VSS   VDDQ
E7   VSS   VDDQ   VSS   VDDQ
E8   VSS   VDDQ   VSS   VDDQ
E9   NC   VDD
F1   VSS   NC
F2   NC   VDDQ
F3   VSS   NC
F7   VSS   NC
F8   NC   VDDQ
F9   VSS   NC
G1   NC   NC   VSS   VDDQ
G2   NC   NC   VSS   VDDQ
G3   NC   VDD
G7   NC   VDDQ   VSS   VDDQ
G8   NC   VDDQ
G9   NC   NC   VSS   VDDQ
H1   VSS   VDDQ   VSS   VDDQ
H2   VSS   NC
H3   NC   VDDQ   VSS   VDDQ
H7   NC   VDDQ   VSS   VDDQ
H8   VSS   NC
H9   NC   VDD
J1   NC   VDDQ
J2   NC   VDDQ   VSS   VDDQ
J3   NC   VDDQ   VSS   VDDQ
J7   NC   VDDQ   VSS   VDDQ
J8   NC   VDDQ   VSS   VDDQ
J9   NC   VDDQ
K1   NC   VDD
K2   NC   VDDQ   VSS   VDDQ
K3   NC   VDDQ   VSS   VDDQ
K7   NC   VDDQ   VSS   VDDQ
K8   NC   VDDQ   VSS   VDDQ
K9   NC   VDD
L1   NC   VDDQ
L2   VSS   NC
L3   NC   VDDQ   VSS   VDDQ
L7   NC   VDDQ   VSS   VDDQ
L8   VSS   NC
L9   NC   VDDQ
M1   NC   NC   VSS   VDDQ
M2   NC   VDDQ   VSS   VDDQ
M3   NC   VDDQ   VSS   VDDQ
M7   NC   VDDQ   VSS   VDDQ
M8   NC   VDDQ   VSS   VDDQ
M9   NC   NC   VSS   VDDQ
N1   NC   VDD
N2   VSS   NC
N3   NC   VDD
N7   NC   VPP
N8   VSS   NC
N9   NC   VDD
|**********************DIFF PIN*********************************************
[Diff_pin]   inv_pin   vdiff   tdelay_typ   tdelay_min   tdelay_max
   C3   D3   0.150V   0ns   NA   NA
   G7   H7   0.150V   0ns   NA   NA
| COMPONENT: MT60B1G16HC (102-Ball FBGA, x16)
[Component]   MT60B1G16HC
[Package Model] y32a_102ball_pkg
[Manufacturer]  Micron Technology,Inc.
[Package]
|   typ   min   max
R_pkg   0.820   0.497   1.340
L_pkg   2.012nH   1.175nH   3.610nH
C_pkg   0.451pF   0.282pF   0.886pF
[Pin]   signal_name   model_name   R_pin   L_pin   C_pin   | TD_pin(ps)   Z_pin
A1   LBDQ   LBDQ   1.068   2.536nH   0.642pF   | 40.338   62.867
A2   VSS   GND
A3   VPP   POWER
A7   ZQ   NC
A8   VSS   GND
A9   LBDQS   LBDQ   1.064   2.506nH   0.654pF   | 40.475   61.910
B1   VDD   POWER
B2   VDDQ   POWER
B3   DQU2   DQ   0.805   1.923nH   0.491pF   | 30.715   62.595
B7   DQU3   DQ   0.802   1.927nH   0.496pF   | 30.914   62.317
B8   VDDQ   POWER
B9   VDD   POWER
C1   VSS   GND
C2   DQU0   DQ   0.821   1.890nH   0.499pF   | 30.722   61.512
C3   DQSU_T   DQS   0.804   2.132nH   0.525pF   | 33.463   63.707
C7   DMU_N   DM_TDQS   0.815   2.247nH   0.488pF   | 33.117   67.838
C8   DQU1   DQ   0.823   1.871nH   0.505pF   | 30.730   60.879
C9   VSS   GND
D1   VDDQ   POWER
D2   VSS   GND
D3   DQSU_C   DQS   0.811   2.094nH   0.525pF   | 33.164   63.145
D7   RFU1   NC
D8   VSS   GND
D9   VDDQ   POWER
E1   VDD   POWER
E2   DQU4   DQ   0.813   1.888nH   0.461pF   | 29.485   64.025
E3   DQU6   DQ   0.779   1.824nH   0.398pF   | 26.925   67.727
E7   DQU7   DQ   0.759   1.846nH   0.400pF   | 27.167   67.966
E8   DQU5   DQ   0.817   1.916nH   0.465pF   | 29.842   64.213
E9   VDD   POWER
F1   VDD   POWER
F2   VDDQ   POWER
F3   DQL2   DQ   0.655   1.484nH   0.383pF   | 23.850   62.240
F7   DQL3   DQ   0.659   1.478nH   0.370pF   | 23.397   63.191
F8   VDDQ   POWER
F9   VDD   POWER
G1   VSS   GND
G2   DQL0   DQ   0.652   1.501nH   0.404pF   | 24.624   60.940
G3   DQSL_T   DQS   0.655   1.794nH   0.433pF   | 27.879   64.366
G7   DML_N   DM_TDQS   0.652   1.683nH   0.407pF   | 26.173   64.297
G8   DQL1   DQ   0.650   1.470nH   0.404pF   | 24.364   60.331
G9   VSS   GND
H1   VDDQ   POWER
H2   VSS   GND
H3   DQSL_C   DQS   0.654   1.717nH   0.432pF   | 27.230   63.055
H7   RFU2   NC
H8   VSS   GND
H9   VDDQ   POWER
J1   VDD   POWER
J2   DQL4   DQ   0.650   1.503nH   0.390pF   | 24.226   62.055
J3   DQL6   DQ   0.647   1.544nH   0.428pF   | 25.714   60.044
J7   DQL7   DQ   0.653   1.531nH   0.436pF   | 25.831   59.253
J8   DQL5   DQ   0.656   1.500nH   0.399pF   | 24.454   61.359
J9   VDD   POWER
K1   VSS   GND
K2   VDDQ   POWER
K3   VSS   GND
K7   VSS   GND
K8   VDDQ   POWER
K9   VSS   GND
L1   CA_ODT   CTRL   0.706   1.835nH   0.447pF   | 28.658   64.047
L2   MIR   CTRL   1.296   3.318nH   0.927pF   | 55.462   59.828
L3   VDD   POWER
L7   CK_T   CLK_INPUT   0.546   1.373nH   0.299pF   | 20.244   67.807
L8   VDDQ   POWER
L9   TEN   CTRL   1.271   3.487nH   0.946pF   | 57.426   60.723
M1   ALERT_N   ALERT   0.809   2.355nH   0.505pF   | 34.480   68.303
M2   VSS   GND
M3   CS_N   CS_INPUT   0.487   1.157nH   0.304pF   | 18.754   61.692
M7   CK_C   CLK_INPUT   0.527   1.403nH   0.328pF   | 21.466   65.382
M8   VSSDL   GND
M9   VDDL   POWER
N1   VDDQ   POWER
N2   CA4   CA_INPUT   0.848   1.960nH   0.516pF   | 31.785   61.653
N3   CA0   CA_INPUT   0.854   2.113nH   0.452pF   | 30.895   68.388
N7   CA1   CA_INPUT   0.853   2.084nH   0.450pF   | 30.615   68.078
N8   CA5   CA_INPUT   0.858   2.097nH   0.513pF   | 32.804   63.921
N9   VDDQ   POWER
P1   VDD   POWER
P2   CA6   CA_INPUT   0.844   1.990nH   0.509pF   | 31.838   62.498
P3   CA2   CA_INPUT   0.853   2.141nH   0.450pF   | 31.023   69.003
P7   CA3   CA_INPUT   0.844   2.204nH   0.456pF   | 31.701   69.537
P8   CA7   CA_INPUT   0.843   2.026nH   0.486pF   | 31.386   64.555
P9   VDD   POWER
R1   VDDQ   POWER
R2   VSS   GND
R3   CA8   CA_INPUT   0.872   2.124nH   0.497pF   | 32.488   65.368
R7   CA9   CA_INPUT   0.856   2.123nH   0.487pF   | 32.166   65.996
R8   VSS   GND
R9   VDDQ   POWER
T1   CAI   CTRL   1.097   2.575nH   0.788pF   | 45.057   57.155
T2   CA10   CA_INPUT   0.867   2.017nH   0.521pF   | 32.410   62.239
T3   CA12   CA_INPUT   0.871   2.075nH   0.510pF   | 32.534   63.774
T7   CA13   CA_INPUT   0.866   2.080nH   0.480pF   | 31.585   65.862
T8   CA11   CA_INPUT   0.863   2.009nH   0.511pF   | 32.025   62.725
T9   RESET_N   CTRL   1.020   2.741nH   0.754pF   | 45.472   60.281
U1   VDD   POWER
U2   VSS   GND
U3   VDD   POWER
U7   VPP   POWER
U8   VSS   GND
U9   VDD   POWER
|***********************PIN MAPPING*****************************************
[Pin Mapping]   pulldown_ref   pullup_ref   gnd_clamp_ref   power_clamp_ref  ext_ref
A1   VSS   VDDQ   VSS   VDDQ
A2   VSS   NC
A3   NC   VPP
A7   NC   NC
A8   VSS   NC
A9   VSS   VDDQ   VSS   VDDQ
B1   NC   VDD
B2   NC   VDDQ
B3   VSS   VDDQ   VSS   VDDQ
B7   VSS   VDDQ   VSS   VDDQ
B8   NC   VDDQ
B9   NC   VDD
C1   VSS   NC
C2   VSS   VDDQ   VSS   VDDQ
C3   VSS   VDDQ   VSS   VDDQ
C7   NC   NC   VSS   VDDQ
C8   VSS   VDDQ   VSS   VDDQ
C9   VSS   NC
D1   NC   VDDQ
D2   VSS   NC
D3   VSS   VDDQ   VSS   VDDQ
D7   NC   NC
D8   VSS   NC
D9   NC   VDDQ
E1   NC   VDD
E2   VSS   VDDQ   VSS   VDDQ
E3   VSS   VDDQ   VSS   VDDQ
E7   VSS   VDDQ   VSS   VDDQ
E8   VSS   VDDQ   VSS   VDDQ
E9   NC   VDD
F1   NC   VDD
F2   NC   VDDQ
F3   VSS   VDDQ   VSS   VDDQ
F7   VSS   VDDQ   VSS   VDDQ
F8   NC   VDDQ
F9   NC   VDD
G1   VSS   NC
G2   VSS   VDDQ   VSS   VDDQ
G3   VSS   VDDQ   VSS   VDDQ
G7   NC   NC   VSS   VDDQ
G8   VSS   VDDQ   VSS   VDDQ
G9   VSS   NC
H1   NC   VDDQ
H2   VSS   NC
H3   VSS   VDDQ   VSS   VDDQ
H7   NC   NC
H8   VSS   NC
H9   NC   VDDQ
J1   NC   VDD
J2   VSS   VDDQ   VSS   VDDQ
J3   VSS   VDDQ   VSS   VDDQ
J7   VSS   VDDQ   VSS   VDDQ
J8   VSS   VDDQ   VSS   VDDQ
J9   NC   VDD
K1   VSS   NC
K2   NC   VDDQ
K3   VSS   NC
K7   VSS   NC
K8   NC   VDDQ
K9   VSS   NC
L1   NC   VDDQ   VSS   VDDQ
L2   NC   VDDQ   VSS   VDDQ
L3   NC   VDD
L7   NC   VDDQ   VSS   VDDQ
L8   NC   VDDQ
L9   NC   VDDQ   VSS   VDDQ
M1   VSS   VDDQ   VSS   VDDQ
M2   VSS   NC
M3   NC   VDDQ   VSS   VDDQ
M7   NC   VDDQ   VSS   VDDQ
M8   VSS   NC
M9   NC   VDD
N1   NC   VDDQ
N2   NC   VDDQ   VSS   VDDQ
N3   NC   VDDQ   VSS   VDDQ
N7   NC   VDDQ   VSS   VDDQ
N8   NC   VDDQ   VSS   VDDQ
N9   NC   VDDQ
P1   NC   VDD
P2   NC   VDDQ   VSS   VDDQ
P3   NC   VDDQ   VSS   VDDQ
P7   NC   VDDQ   VSS   VDDQ
P8   NC   VDDQ   VSS   VDDQ
P9   NC   VDD
R1   NC   VDDQ
R2   VSS   NC
R3   NC   VDDQ   VSS   VDDQ
R7   NC   VDDQ   VSS   VDDQ
R8   VSS   NC
R9   NC   VDDQ
T1   NC   VDDQ   VSS   VDDQ
T2   NC   VDDQ   VSS   VDDQ
T3   NC   VDDQ   VSS   VDDQ
T7   NC   VDDQ   VSS   VDDQ
T8   NC   VDDQ   VSS   VDDQ
T9   NC   VDDQ   VSS   VDDQ
U1   NC   VDD
U2   VSS   NC
U3   NC   VDD
U7   NC   VPP
U8   VSS   NC
U9   NC   VDD
|**********************DIFF PIN*********************************************
[Diff_pin]   inv_pin   vdiff   tdelay_typ   tdelay_min   tdelay_max
   C3   D3   0.150V   0ns   NA   NA
   G3   H3   0.150V   0ns   NA   NA
   L7   M7   0.150V   0ns   NA   NA
|   Model Selector
[Model Selector] DQ
DQ_34_4800   34 Ohm Data I/O with no ODT, 4800 Mbps
DQ_40_4800   40 Ohm Data I/O with no ODT, 4800 Mbps
DQ_48_4800   48 Ohm Data I/O with no ODT, 4800 Mbps
DQ_IN_ODTOFF_4800  Data Input with ODT off, 4800 Mbps
DQ_IN_ODT34_4800   Data Input with 34ohm ODT, 4800 Mbps
DQ_IN_ODT40_4800   Data Input with 40ohm ODT, 4800 Mbps
DQ_IN_ODT48_4800   Data Input with 48ohm ODT, 4800 Mbps
DQ_IN_ODT60_4800   Data Input with 60ohm ODT, 4800 Mbps
DQ_IN_ODT80_4800   Data Input with 80ohm ODT, 4800 Mbps
DQ_IN_ODT120_4800  Data Input with 120ohm ODT, 4800 Mbps
DQ_IN_ODT240_4800  Data Input with 240ohm ODT, 4800 Mbps
[Model Selector] DQS
DQS_34_4800   34 Ohm Data Strobe I/O with no ODT, 4800 Mbps
DQS_40_4800   40 Ohm Data Strobe I/O with no ODT, 4800 Mbps
DQS_48_4800   48 Ohm Data Strobe I/O with no ODT, 4800 Mbps
DQS_IN_ODTOFF_4800 Data Strobe Input with ODT off, 4800 Mbps
DQS_IN_ODT34_4800  Data Strobe Input with 34ohm ODT, 4800 Mbps
DQS_IN_ODT40_4800  Data Strobe Input with 40ohm ODT, 4800 Mbps
DQS_IN_ODT48_4800  Data Strobe Input with 48ohm ODT, 4800 Mbps
DQS_IN_ODT60_4800  Data Strobe Input with 60ohm ODT, 4800 Mbps
DQS_IN_ODT80_4800  Data Strobe Input with 80ohm ODT, 4800 Mbps
DQS_IN_ODT120_4800 Data Strobe Input with 120ohm ODT, 4800 Mbps
DQS_IN_ODT240_4800 Data Strobe Input with 240ohm ODT, 4800 Mbps
[Model Selector] LBDQ
LBDQ_34_4800   34 Ohm 3-state with no ODT, 4800 Mbps
LBDQ_ODTOFF_4800   LBDQ Terminator Model with ODT off, 4800 Mbps
LBDQ_ODT48_4800   LBDQ Terminator Model with 48ohm ODT, 4800 Mbps
[Model Selector] TDQS
TDQS_ODTOFF_4800   TDQS Terminator Model with ODT off, 4800 Mbps
TDQS_ODT34_4800   TDQS Terminator Model with 34ohm ODT, 4800 Mbps
TDQS_ODT40_4800   TDQS Terminator Model with 40ohm ODT, 4800 Mbps
TDQS_ODT48_4800   TDQS Terminator Model with 48ohm ODT, 4800 Mbps
TDQS_ODT60_4800   TDQS Terminator Model with 60ohm ODT, 4800 Mbps
TDQS_ODT80_4800   TDQS Terminator Model with 80ohm ODT, 4800 Mbps
TDQS_ODT120_4800   TDQS Terminator Model with 120ohm ODT, 4800 Mbps
TDQS_ODT240_4800   TDQS Terminator Model with 240ohm ODT, 4800 Mbps
NF_DQ   Non-Functioning Terminator Model
[Model Selector] DM_TDQS
DM_ODTOFF_4800   DM Input Model with no ODT, 4800 Mbps
DM_ODT34_4800   DM Input Model with 34ohm ODT, 4800 Mbps
DM_ODT40_4800   DM Input Model with 40ohm ODT, 4800 Mbps
DM_ODT48_4800   DM Input Model with 48ohm ODT, 4800 Mbps
DM_ODT60_4800   DM Input Model with 60ohm ODT, 4800 Mbps
DM_ODT80_4800   DM Input Model with 80ohm ODT, 4800 Mbps
DM_ODT120_4800   DM Input Model with 120ohm ODT, 4800 Mbps
DM_ODT240_4800   DM Input Model with 240ohm ODT, 4800 Mbps
TDQS_ODTOFF_4800   TDQS Terminator Model with ODT off, 4800 Mbps
TDQS_ODT34_4800   TDQS Terminator Model with 34ohm ODT, 4800 Mbps
TDQS_ODT40_4800   TDQS Terminator Model with 40ohm ODT, 4800 Mbps
TDQS_ODT48_4800   TDQS Terminator Model with 48ohm ODT, 4800 Mbps
TDQS_ODT60_4800   TDQS Terminator Model with 60ohm ODT, 4800 Mbps
TDQS_ODT80_4800   TDQS Terminator Model with 80ohm ODT, 4800 Mbps
TDQS_ODT120_4800   TDQS Terminator Model with 120ohm ODT, 4800 Mbps
TDQS_ODT240_4800   TDQS Terminator Model with 240ohm ODT, 4800 Mbps
NF_DQ   Non-Functioning Terminator Model
[Model Selector] CA_INPUT
CA_INPUT_ODTOFF_4800   Add/Cmd Input Model with ODT off, 4800 Mbps
CA_INPUT_ODT40_4800   Add/Cmd Input Model with 40ohm ODT, 4800 Mbps
CA_INPUT_ODT60_4800   Add/Cmd Input Model with 60ohm ODT, 4800 Mbps
CA_INPUT_ODT80_4800   Add/Cmd Input Model with 80ohm ODT, 4800 Mbps
CA_INPUT_ODT240_4800   Add/Cmd Input Model with 240ohm ODT, 4800 Mbps
CA_INPUT_ODT480_4800   Add/Cmd Input Model with 480ohm ODT, 4800 Mbps
[Model Selector] CLK_INPUT
CLK_INPUT_ODTOFF_4800   Clock Input Model with ODT off, 4800 Mbps
CLK_INPUT_ODT40_4800   Clock Input Model with 40ohm ODT, 4800 Mbps
CLK_INPUT_ODT60_4800   Clock Input Model with 60ohm ODT, 4800 Mbps
CLK_INPUT_ODT80_4800   Clock Input Model with 80ohm ODT, 4800 Mbps
CLK_INPUT_ODT240_4800   Clock Input Model with 240ohm ODT, 4800 Mbps
CLK_INPUT_ODT480_4800   Clock Input Model with 480ohm ODT, 4800 Mbps
[Model Selector] CS_INPUT
CS_INPUT_ODTOFF_4800   CS Input Model with ODT off, 4800 Mbps
CS_INPUT_ODT40_4800   CS Input Model with 40ohm ODT, 4800 Mbps
CS_INPUT_ODT60_4800   CS Input Model with 60ohm ODT, 4800 Mbps
CS_INPUT_ODT80_4800   CS Input Model with 80ohm ODT, 4800 Mbps
CS_INPUT_ODT240_4800   CS Input Model with 240ohm ODT, 4800 Mbps
CS_INPUT_ODT480_4800   CS Input Model with 480ohm ODT, 4800 Mbps
| Sparse Matrix Package Model for y32a_78ball_pkg (x8)
[Define Package Model]  y32a_78ball_pkg
[Manufacturer]   Micron Technology, Inc.
[OEM]   Micron Technology, Inc.
[Description]   y32a package model for 78-ball x8 VFBGA
[Number of Pins]   45
[Pin Numbers]
A1  | LBDQS
A2  | VSS
A3  | VPP_A3
A7  | ZQ
A9  | LBDQ
B3  | DQ2
B7  | DQ3
C2  | DQ0
C3  | DQS_T
C7  | DM_N
C8  | DQ1
D3  | DQS_C
D7  | TDQS_C
E1  | VDD
E2  | DQ4
E3  | DQ6
E7  | DQ7
E8  | DQ5
G1  | ODT
G2  | MIRROR
G7  | CK_T
G9  | TEN
H1  | ALERT_N
H3  | CS_N
H7  | CK_C
H8  | VSSDL
J1  | VDDQ_SUBNET_1
J2  | CA4
J3  | CA0
J7  | CA1
J8  | CA5
J9  | VDDQ_SUBNET_0
K2  | CA6
K3  | CA2
K7  | CA3
K8  | CA7
L3  | CA8
L7  | CA9
M1  | CAI
M2  | CA10
M3  | CA12
M7  | CA13
M8  | CA11
M9  | RESET_N
N7  | VPP_N7
[Model Data]
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[End Model Data]
[End Package Model]
| Sparse Matrix Package Model for y32a_102ball_pkg (x8)
[Define Package Model]  y32a_102ball_pkg
[Manufacturer]   Micron Technology, Inc.
[OEM]   Micron Technology, Inc.
[Description]   y32a package model for 102-ball x16 VFBGA
[Number of Pins]   54
[Pin Numbers]
A1  | LBDQ
A2  | VSS
A3  | VPP_A3
A7  | ZQ
A9  | LBDQS
B3  | DQU2
B7  | DQU3
C2  | DQU0
C3  | DQSU_T
C7  | DMU_N
C8  | DQU1
D3  | DQSU_C
E1  | VDD
E2  | DQU4
E3  | DQU6
E7  | DQU7
E8  | DQU5
F3  | DQL2
F7  | DQL3
G2  | DQL0
G3  | DQSL_T
G7  | DML_N
G8  | DQL1
H3  | DQSL_C
J2  | DQL4
J3  | DQL6
J7  | DQL7
J8  | DQL5
K2  | VDDQ_SUBNET_0
K8  | VDDQ_SUBNET_1
L1  | CA_ODT
L2  | MIR
L7  | CK_T
L9  | TEN
M1  | ALERT_N
M3  | CS_N
M7  | CK_C
N2  | CA4
N3  | CA0
N7  | CA1
N8  | CA5
P2  | CA6
P3  | CA2
P7  | CA3
P8  | CA7
R3  | CA8
R7  | CA9
T1  | CAI
T2  | CA10
T3  | CA12
T7  | CA13
T8  | CA11
T9  | RESET_N
U7  | VPP_U7
[Model Data]
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[End Model Data]
[End Package Model]
| Models and submodels in the file (74): DQ_34_4800 (I/O), DQ_40_4800 (I/O), DQ_48_4800 (I/O), DQ_IN_ODTOFF_4800 (Input), DQ_IN_ODT34_4800 (Input), DQ_IN_ODT40_4800 (Input), DQ_IN_ODT48_4800 (Input), DQ_IN_ODT60_4800 (Input), DQ_IN_ODT80_4800 (Input), DQ_IN_ODT120_4800 (Input), DQ_IN_ODT240_4800 (Input), DQS_34_4800 (I/O), DQS_40_4800 (I/O), DQS_48_4800 (I/O), DQS_IN_ODTOFF_4800 (Input), DQS_IN_ODT34_4800 (Input), DQS_IN_ODT40_4800 (Input), DQS_IN_ODT48_4800 (Input), DQS_IN_ODT60_4800 (Input), DQS_IN_ODT80_4800 (Input), DQS_IN_ODT120_4800 (Input), DQS_IN_ODT240_4800 (Input), TDQS_ODTOFF_4800 (Terminator), TDQS_ODT34_4800 (Terminator), TDQS_ODT40_4800 (Terminator), TDQS_ODT48_4800 (Terminator), TDQS_ODT60_4800 (Terminator), TDQS_ODT80_4800 (Terminator), TDQS_ODT120_4800 (Terminator), TDQS_ODT240_4800 (Terminator), DM_ODTOFF_4800 (Input), DM_ODT34_4800 (Input), DM_ODT40_4800 (Input), DM_ODT48_4800 (Input), DM_ODT60_4800 (Input), DM_ODT80_4800 (Input), DM_ODT120_4800 (Input), DM_ODT240_4800 (Input), LBDQ_34_4800 (3-state), LBDQ_ODTOFF_4800 (Terminator), LBDQ_ODT48_4800 (Terminator), CA_INPUT_ODTOFF_4800 (Input), CA_INPUT_ODT40_4800 (Input), CA_INPUT_ODT60_4800 (Input), CA_INPUT_ODT80_4800 (Input), CA_INPUT_ODT240_4800 (Input), CA_INPUT_ODT480_4800 (Input), CLK_INPUT_ODTOFF_4800 (Input), CLK_INPUT_ODT40_4800 (Input), CLK_INPUT_ODT60_4800 (Input), CLK_INPUT_ODT80_4800 (Input), CLK_INPUT_ODT240_4800 (Input), CLK_INPUT_ODT480_4800 (Input), CS_INPUT_ODTOFF_4800 (Input), CS_INPUT_ODT40_4800 (Input), CS_INPUT_ODT60_4800 (Input), CS_INPUT_ODT80_4800 (Input), CS_INPUT_ODT240_4800 (Input), CS_INPUT_ODT480_4800 (Input), CTRL (Input), ALERT (Open_sink), NF_DQ (Terminator), 34ohm_ODT_4800 (Dynamic_clamp), 40ohm_ODT_4800 (Dynamic_clamp), 48ohm_ODT_4800 (Dynamic_clamp), 60ohm_ODT_4800 (Dynamic_clamp), 80ohm_ODT_4800 (Dynamic_clamp), 120ohm_ODT_4800 (Dynamic_clamp), 240ohm_ODT_4800 (Dynamic_clamp), 40ohm_CAODT_4800 (Dynamic_clamp), 60ohm_CAODT_4800 (Dynamic_clamp), 80ohm_CAODT_4800 (Dynamic_clamp), 240ohm_CAODT_4800 (Dynamic_clamp), 480ohm_CAODT_4800 (Dynamic_clamp)
