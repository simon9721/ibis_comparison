* Edge-family stress: ngspice refspice, ui1_len30cm_loss1
* channel delay exceeds UI
* UI=1.000 ns, stop=200.000 ns
* channel_sections=30, channel_delay=2.076 ns, loss_scale=1

.temp 27
.options method=gear maxord=2 reltol=1e-3 abstol=1e-9 vntol=1e-5 gmin=1e-10 trtol=10

* Inline PRBS7 V-source PWL stimulus
* 200 bits, UI=1.000 ns, tr/tf=200 ps
Vstim  in_src  0  PWL(0.000000000e+00 0.0000
+ 1.000000000e-09  0.0000
+ 2.000000000e-09  0.0000
+ 3.000000000e-09  0.0000
+ 4.000000000e-09  0.0000
+ 5.000000000e-09  0.0000
+ 6.000000000e-09  0.0000
+ 7.000000000e-09  0.0000
+ 7.200000000e-09  3.3000
+ 8.000000000e-09  3.3000
+ 9.000000000e-09  3.3000
+ 1.000000000e-08  3.3000
+ 1.100000000e-08  3.3000
+ 1.200000000e-08  3.3000
+ 1.300000000e-08  3.3000
+ 1.320000000e-08  0.0000
+ 1.400000000e-08  0.0000
+ 1.420000000e-08  3.3000
+ 1.500000000e-08  3.3000
+ 1.600000000e-08  3.3000
+ 1.700000000e-08  3.3000
+ 1.800000000e-08  3.3000
+ 1.900000000e-08  3.3000
+ 1.920000000e-08  0.0000
+ 2.000000000e-08  0.0000
+ 2.100000000e-08  0.0000
+ 2.120000000e-08  3.3000
+ 2.200000000e-08  3.3000
+ 2.300000000e-08  3.3000
+ 2.400000000e-08  3.3000
+ 2.500000000e-08  3.3000
+ 2.520000000e-08  0.0000
+ 2.600000000e-08  0.0000
+ 2.620000000e-08  3.3000
+ 2.700000000e-08  3.3000
+ 2.720000000e-08  0.0000
+ 2.800000000e-08  0.0000
+ 2.820000000e-08  3.3000
+ 2.900000000e-08  3.3000
+ 3.000000000e-08  3.3000
+ 3.100000000e-08  3.3000
+ 3.120000000e-08  0.0000
+ 3.200000000e-08  0.0000
+ 3.300000000e-08  0.0000
+ 3.400000000e-08  0.0000
+ 3.500000000e-08  0.0000
+ 3.520000000e-08  3.3000
+ 3.600000000e-08  3.3000
+ 3.700000000e-08  3.3000
+ 3.720000000e-08  0.0000
+ 3.800000000e-08  0.0000
+ 3.820000000e-08  3.3000
+ 3.900000000e-08  3.3000
+ 4.000000000e-08  3.3000
+ 4.100000000e-08  3.3000
+ 4.120000000e-08  0.0000
+ 4.200000000e-08  0.0000
+ 4.220000000e-08  3.3000
+ 4.300000000e-08  3.3000
+ 4.320000000e-08  0.0000
+ 4.400000000e-08  0.0000
+ 4.500000000e-08  0.0000
+ 4.520000000e-08  3.3000
+ 4.600000000e-08  3.3000
+ 4.700000000e-08  3.3000
+ 4.720000000e-08  0.0000
+ 4.800000000e-08  0.0000
+ 4.900000000e-08  0.0000
+ 5.000000000e-08  0.0000
+ 5.020000000e-08  3.3000
+ 5.100000000e-08  3.3000
+ 5.120000000e-08  0.0000
+ 5.200000000e-08  0.0000
+ 5.220000000e-08  3.3000
+ 5.300000000e-08  3.3000
+ 5.320000000e-08  0.0000
+ 5.400000000e-08  0.0000
+ 5.420000000e-08  3.3000
+ 5.500000000e-08  3.3000
+ 5.600000000e-08  3.3000
+ 5.620000000e-08  0.0000
+ 5.700000000e-08  0.0000
+ 5.800000000e-08  0.0000
+ 5.900000000e-08  0.0000
+ 6.000000000e-08  0.0000
+ 6.100000000e-08  0.0000
+ 6.120000000e-08  3.3000
+ 6.200000000e-08  3.3000
+ 6.220000000e-08  0.0000
+ 6.300000000e-08  0.0000
+ 6.320000000e-08  3.3000
+ 6.400000000e-08  3.3000
+ 6.500000000e-08  3.3000
+ 6.600000000e-08  3.3000
+ 6.700000000e-08  3.3000
+ 6.720000000e-08  0.0000
+ 6.800000000e-08  0.0000
+ 6.900000000e-08  0.0000
+ 7.000000000e-08  0.0000
+ 7.020000000e-08  3.3000
+ 7.100000000e-08  3.3000
+ 7.200000000e-08  3.3000
+ 7.300000000e-08  3.3000
+ 7.320000000e-08  0.0000
+ 7.400000000e-08  0.0000
+ 7.420000000e-08  3.3000
+ 7.500000000e-08  3.3000
+ 7.600000000e-08  3.3000
+ 7.620000000e-08  0.0000
+ 7.700000000e-08  0.0000
+ 7.720000000e-08  3.3000
+ 7.800000000e-08  3.3000
+ 7.900000000e-08  3.3000
+ 7.920000000e-08  0.0000
+ 8.000000000e-08  0.0000
+ 8.100000000e-08  0.0000
+ 8.120000000e-08  3.3000
+ 8.200000000e-08  3.3000
+ 8.220000000e-08  0.0000
+ 8.300000000e-08  0.0000
+ 8.400000000e-08  0.0000
+ 8.420000000e-08  3.3000
+ 8.500000000e-08  3.3000
+ 8.520000000e-08  0.0000
+ 8.600000000e-08  0.0000
+ 8.620000000e-08  3.3000
+ 8.700000000e-08  3.3000
+ 8.720000000e-08  0.0000
+ 8.800000000e-08  0.0000
+ 8.900000000e-08  0.0000
+ 8.920000000e-08  3.3000
+ 9.000000000e-08  3.3000
+ 9.020000000e-08  0.0000
+ 9.100000000e-08  0.0000
+ 9.200000000e-08  0.0000
+ 9.300000000e-08  0.0000
+ 9.400000000e-08  0.0000
+ 9.420000000e-08  3.3000
+ 9.500000000e-08  3.3000
+ 9.520000000e-08  0.0000
+ 9.600000000e-08  0.0000
+ 9.700000000e-08  0.0000
+ 9.720000000e-08  3.3000
+ 9.800000000e-08  3.3000
+ 9.900000000e-08  3.3000
+ 1.000000000e-07  3.3000
+ 1.002000000e-07  0.0000
+ 1.010000000e-07  0.0000
+ 1.020000000e-07  0.0000
+ 1.022000000e-07  3.3000
+ 1.030000000e-07  3.3000
+ 1.032000000e-07  0.0000
+ 1.040000000e-07  0.0000
+ 1.042000000e-07  3.3000
+ 1.050000000e-07  3.3000
+ 1.060000000e-07  3.3000
+ 1.062000000e-07  0.0000
+ 1.070000000e-07  0.0000
+ 1.072000000e-07  3.3000
+ 1.080000000e-07  3.3000
+ 1.082000000e-07  0.0000
+ 1.090000000e-07  0.0000
+ 1.100000000e-07  0.0000
+ 1.110000000e-07  0.0000
+ 1.112000000e-07  3.3000
+ 1.120000000e-07  3.3000
+ 1.122000000e-07  0.0000
+ 1.130000000e-07  0.0000
+ 1.140000000e-07  0.0000
+ 1.150000000e-07  0.0000
+ 1.152000000e-07  3.3000
+ 1.160000000e-07  3.3000
+ 1.170000000e-07  3.3000
+ 1.172000000e-07  0.0000
+ 1.180000000e-07  0.0000
+ 1.190000000e-07  0.0000
+ 1.192000000e-07  3.3000
+ 1.200000000e-07  3.3000
+ 1.210000000e-07  3.3000
+ 1.212000000e-07  0.0000
+ 1.220000000e-07  0.0000
+ 1.222000000e-07  3.3000
+ 1.230000000e-07  3.3000
+ 1.232000000e-07  0.0000
+ 1.240000000e-07  0.0000
+ 1.242000000e-07  3.3000
+ 1.250000000e-07  3.3000
+ 1.252000000e-07  0.0000
+ 1.260000000e-07  0.0000
+ 1.262000000e-07  3.3000
+ 1.270000000e-07  3.3000
+ 1.272000000e-07  0.0000
+ 1.280000000e-07  0.0000
+ 1.290000000e-07  0.0000
+ 1.300000000e-07  0.0000
+ 1.310000000e-07  0.0000
+ 1.320000000e-07  0.0000
+ 1.330000000e-07  0.0000
+ 1.340000000e-07  0.0000
+ 1.342000000e-07  3.3000
+ 1.350000000e-07  3.3000
+ 1.360000000e-07  3.3000
+ 1.370000000e-07  3.3000
+ 1.380000000e-07  3.3000
+ 1.390000000e-07  3.3000
+ 1.400000000e-07  3.3000
+ 1.402000000e-07  0.0000
+ 1.410000000e-07  0.0000
+ 1.412000000e-07  3.3000
+ 1.420000000e-07  3.3000
+ 1.430000000e-07  3.3000
+ 1.440000000e-07  3.3000
+ 1.450000000e-07  3.3000
+ 1.460000000e-07  3.3000
+ 1.462000000e-07  0.0000
+ 1.470000000e-07  0.0000
+ 1.480000000e-07  0.0000
+ 1.482000000e-07  3.3000
+ 1.490000000e-07  3.3000
+ 1.500000000e-07  3.3000
+ 1.510000000e-07  3.3000
+ 1.520000000e-07  3.3000
+ 1.522000000e-07  0.0000
+ 1.530000000e-07  0.0000
+ 1.532000000e-07  3.3000
+ 1.540000000e-07  3.3000
+ 1.542000000e-07  0.0000
+ 1.550000000e-07  0.0000
+ 1.552000000e-07  3.3000
+ 1.560000000e-07  3.3000
+ 1.570000000e-07  3.3000
+ 1.580000000e-07  3.3000
+ 1.582000000e-07  0.0000
+ 1.590000000e-07  0.0000
+ 1.600000000e-07  0.0000
+ 1.610000000e-07  0.0000
+ 1.620000000e-07  0.0000
+ 1.622000000e-07  3.3000
+ 1.630000000e-07  3.3000
+ 1.640000000e-07  3.3000
+ 1.642000000e-07  0.0000
+ 1.650000000e-07  0.0000
+ 1.652000000e-07  3.3000
+ 1.660000000e-07  3.3000
+ 1.670000000e-07  3.3000
+ 1.680000000e-07  3.3000
+ 1.682000000e-07  0.0000
+ 1.690000000e-07  0.0000
+ 1.692000000e-07  3.3000
+ 1.700000000e-07  3.3000
+ 1.702000000e-07  0.0000
+ 1.710000000e-07  0.0000
+ 1.720000000e-07  0.0000
+ 1.722000000e-07  3.3000
+ 1.730000000e-07  3.3000
+ 1.740000000e-07  3.3000
+ 1.742000000e-07  0.0000
+ 1.750000000e-07  0.0000
+ 1.760000000e-07  0.0000
+ 1.770000000e-07  0.0000
+ 1.772000000e-07  3.3000
+ 1.780000000e-07  3.3000
+ 1.782000000e-07  0.0000
+ 1.790000000e-07  0.0000
+ 1.792000000e-07  3.3000
+ 1.800000000e-07  3.3000
+ 1.802000000e-07  0.0000
+ 1.810000000e-07  0.0000
+ 1.812000000e-07  3.3000
+ 1.820000000e-07  3.3000
+ 1.830000000e-07  3.3000
+ 1.832000000e-07  0.0000
+ 1.840000000e-07  0.0000
+ 1.850000000e-07  0.0000
+ 1.860000000e-07  0.0000
+ 1.870000000e-07  0.0000
+ 1.880000000e-07  0.0000
+ 1.882000000e-07  3.3000
+ 1.890000000e-07  3.3000
+ 1.892000000e-07  0.0000
+ 1.900000000e-07  0.0000
+ 1.902000000e-07  3.3000
+ 1.910000000e-07  3.3000
+ 1.920000000e-07  3.3000
+ 1.930000000e-07  3.3000
+ 1.940000000e-07  3.3000
+ 1.942000000e-07  0.0000
+ 1.950000000e-07  0.0000
+ 1.960000000e-07  0.0000
+ 1.970000000e-07  0.0000
+ 1.972000000e-07  3.3000
+ 1.980000000e-07  3.3000
+ 1.990000000e-07  3.3000
+ 2.000000000e-07  3.3000)
Rin    in_src  in_dig  1

Vdd_ref  vdd_ref_src  0  DC 3.3
Voe_ref  oe_ref_src   0  DC 3.3
Rvdd_ref vdd_ref_src  vdd_ref  1
Roe_ref  oe_ref_src   oe_ref   1
Cdec_ref vdd_ref      0        10p

.subckt SPICE_BUF in oe out in_sense vdd vss
.include '../../../../models/hspice_ngspice.mod'
.include '../../../../models/io_buf.sp'
.ends SPICE_BUF

XREF in_dig oe_ref pad_ref in_sense_ref vdd_ref 0 SPICE_BUF

RCH_TX  pad_ref tx_out 1u
* Generated 30-section RLGC ladder
* length_scale=3, loss_scale=1
* nominal one-way delay=2.076 ns
RCH1   tx_out   s1a      0.05
LCH1   s1a      s1b      3.460000000e-09
CCH1   s1b      0        1.384000000e-12
GCH1   s1b      0        value={1.000000000e-06*v(s1b,0)}
RCH2   s1b      s2a      0.05
LCH2   s2a      s2b      3.460000000e-09
CCH2   s2b      0        1.384000000e-12
GCH2   s2b      0        value={1.000000000e-06*v(s2b,0)}
RCH3   s2b      s3a      0.05
LCH3   s3a      s3b      3.460000000e-09
CCH3   s3b      0        1.384000000e-12
GCH3   s3b      0        value={1.000000000e-06*v(s3b,0)}
RCH4   s3b      s4a      0.05
LCH4   s4a      s4b      3.460000000e-09
CCH4   s4b      0        1.384000000e-12
GCH4   s4b      0        value={1.000000000e-06*v(s4b,0)}
RCH5   s4b      s5a      0.05
LCH5   s5a      s5b      3.460000000e-09
CCH5   s5b      0        1.384000000e-12
GCH5   s5b      0        value={1.000000000e-06*v(s5b,0)}
RCH6   s5b      s6a      0.05
LCH6   s6a      s6b      3.460000000e-09
CCH6   s6b      0        1.384000000e-12
GCH6   s6b      0        value={1.000000000e-06*v(s6b,0)}
RCH7   s6b      s7a      0.05
LCH7   s7a      s7b      3.460000000e-09
CCH7   s7b      0        1.384000000e-12
GCH7   s7b      0        value={1.000000000e-06*v(s7b,0)}
RCH8   s7b      s8a      0.05
LCH8   s8a      s8b      3.460000000e-09
CCH8   s8b      0        1.384000000e-12
GCH8   s8b      0        value={1.000000000e-06*v(s8b,0)}
RCH9   s8b      s9a      0.05
LCH9   s9a      s9b      3.460000000e-09
CCH9   s9b      0        1.384000000e-12
GCH9   s9b      0        value={1.000000000e-06*v(s9b,0)}
RCH10  s9b      s10a     0.05
LCH10  s10a     s10b     3.460000000e-09
CCH10  s10b     0        1.384000000e-12
GCH10  s10b     0        value={1.000000000e-06*v(s10b,0)}
RCH11  s10b     s11a     0.05
LCH11  s11a     s11b     3.460000000e-09
CCH11  s11b     0        1.384000000e-12
GCH11  s11b     0        value={1.000000000e-06*v(s11b,0)}
RCH12  s11b     s12a     0.05
LCH12  s12a     s12b     3.460000000e-09
CCH12  s12b     0        1.384000000e-12
GCH12  s12b     0        value={1.000000000e-06*v(s12b,0)}
RCH13  s12b     s13a     0.05
LCH13  s13a     s13b     3.460000000e-09
CCH13  s13b     0        1.384000000e-12
GCH13  s13b     0        value={1.000000000e-06*v(s13b,0)}
RCH14  s13b     s14a     0.05
LCH14  s14a     s14b     3.460000000e-09
CCH14  s14b     0        1.384000000e-12
GCH14  s14b     0        value={1.000000000e-06*v(s14b,0)}
RCH15  s14b     s15a     0.05
LCH15  s15a     s15b     3.460000000e-09
CCH15  s15b     0        1.384000000e-12
GCH15  s15b     0        value={1.000000000e-06*v(s15b,0)}
RCH16  s15b     s16a     0.05
LCH16  s16a     s16b     3.460000000e-09
CCH16  s16b     0        1.384000000e-12
GCH16  s16b     0        value={1.000000000e-06*v(s16b,0)}
RCH17  s16b     s17a     0.05
LCH17  s17a     s17b     3.460000000e-09
CCH17  s17b     0        1.384000000e-12
GCH17  s17b     0        value={1.000000000e-06*v(s17b,0)}
RCH18  s17b     s18a     0.05
LCH18  s18a     s18b     3.460000000e-09
CCH18  s18b     0        1.384000000e-12
GCH18  s18b     0        value={1.000000000e-06*v(s18b,0)}
RCH19  s18b     s19a     0.05
LCH19  s19a     s19b     3.460000000e-09
CCH19  s19b     0        1.384000000e-12
GCH19  s19b     0        value={1.000000000e-06*v(s19b,0)}
RCH20  s19b     s20a     0.05
LCH20  s20a     s20b     3.460000000e-09
CCH20  s20b     0        1.384000000e-12
GCH20  s20b     0        value={1.000000000e-06*v(s20b,0)}
RCH21  s20b     s21a     0.05
LCH21  s21a     s21b     3.460000000e-09
CCH21  s21b     0        1.384000000e-12
GCH21  s21b     0        value={1.000000000e-06*v(s21b,0)}
RCH22  s21b     s22a     0.05
LCH22  s22a     s22b     3.460000000e-09
CCH22  s22b     0        1.384000000e-12
GCH22  s22b     0        value={1.000000000e-06*v(s22b,0)}
RCH23  s22b     s23a     0.05
LCH23  s23a     s23b     3.460000000e-09
CCH23  s23b     0        1.384000000e-12
GCH23  s23b     0        value={1.000000000e-06*v(s23b,0)}
RCH24  s23b     s24a     0.05
LCH24  s24a     s24b     3.460000000e-09
CCH24  s24b     0        1.384000000e-12
GCH24  s24b     0        value={1.000000000e-06*v(s24b,0)}
RCH25  s24b     s25a     0.05
LCH25  s25a     s25b     3.460000000e-09
CCH25  s25b     0        1.384000000e-12
GCH25  s25b     0        value={1.000000000e-06*v(s25b,0)}
RCH26  s25b     s26a     0.05
LCH26  s26a     s26b     3.460000000e-09
CCH26  s26b     0        1.384000000e-12
GCH26  s26b     0        value={1.000000000e-06*v(s26b,0)}
RCH27  s26b     s27a     0.05
LCH27  s27a     s27b     3.460000000e-09
CCH27  s27b     0        1.384000000e-12
GCH27  s27b     0        value={1.000000000e-06*v(s27b,0)}
RCH28  s27b     s28a     0.05
LCH28  s28a     s28b     3.460000000e-09
CCH28  s28b     0        1.384000000e-12
GCH28  s28b     0        value={1.000000000e-06*v(s28b,0)}
RCH29  s28b     s29a     0.05
LCH29  s29a     s29b     3.460000000e-09
CCH29  s29b     0        1.384000000e-12
GCH29  s29b     0        value={1.000000000e-06*v(s29b,0)}
RCH30  s29b     s30a     0.05
LCH30  s30a     n10b     3.460000000e-09
CCH30  n10b     0        1.384000000e-12
GCH30  n10b     0        value={1.000000000e-06*v(n10b,0)}
RTERM   n10b 0 50

.save V(in_dig) V(pad_ref) V(tx_out) V(n10b) V(in_sense_ref)
.ic V(pad_ref)=0 V(tx_out)=0 V(n10b)=0
.tran 1.000000000e-11 2.000000000e-07 uic

.end
