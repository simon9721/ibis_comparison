* Hibiki I3C_TX_0p125mA_tx through Wmodel baseline RLGC conversion
* Baseline conversion uses Ro/Lo/Go/Co only; Rs and Gd are documented but ignored.
* Wmodel source: C:/Users/simom/Desktop/Projects/IBIS_Comparison/pcbauto/Wmodel.sp
* Baseline length: 100 mm, ladder sections: 80
.temp 25
.options method=gear maxord=2 reltol=1e-4 abstol=1e-12 vntol=1e-7 gmin=1e-12
Vin in_dig 0 PWL(0n 0 10n 0 10.005n 1.2 30n 1.2 30.005n 0 50n 0 50.005n 1.2 70n 1.2 70.005n 0 90n 0 90.005n 1.2 110n 1.2 110.005n 0 130n 0 130.005n 1.2 150n 1.2 150.005n 0 170n 0 170.005n 1.2 190n 1.2 190.005n 0 230n 0)
Ven en_sig 0 DC 1.2
Vdd vdd 0 DC 1.2
.include 'C:/Users/simom/Desktop/Projects/IBIS_Comparison/results/hibiki_i3c_tx_0p125ma_wmodel_baseline_ngspice_2026-05-29/converted/hibiki_wmodel_baseline_I3C_TX_0p125mA_tx_Typical.sub'

* Wmodel_Trace01::Sig: Ro/Lo/Go/Co baseline, Rs=0.00126077 ignored, Gd=0 ignored
Xtrace01 src_trace01 in_dig en_sig vdd 0 I3C_TX_0p125mA_tx_OutputInput_Typical
RCH_trace01_1 src_trace01 ch_trace01_1_rl 0.00606066
LCH_trace01_1 ch_trace01_1_rl ch_trace01_1 0.819664n
CCH_trace01_1 ch_trace01_1 0 0.0546267p
RCH_trace01_2 ch_trace01_1 ch_trace01_2_rl 0.00606066
LCH_trace01_2 ch_trace01_2_rl ch_trace01_2 0.819664n
CCH_trace01_2 ch_trace01_2 0 0.0546267p
RCH_trace01_3 ch_trace01_2 ch_trace01_3_rl 0.00606066
LCH_trace01_3 ch_trace01_3_rl ch_trace01_3 0.819664n
CCH_trace01_3 ch_trace01_3 0 0.0546267p
RCH_trace01_4 ch_trace01_3 ch_trace01_4_rl 0.00606066
LCH_trace01_4 ch_trace01_4_rl ch_trace01_4 0.819664n
CCH_trace01_4 ch_trace01_4 0 0.0546267p
RCH_trace01_5 ch_trace01_4 ch_trace01_5_rl 0.00606066
LCH_trace01_5 ch_trace01_5_rl ch_trace01_5 0.819664n
CCH_trace01_5 ch_trace01_5 0 0.0546267p
RCH_trace01_6 ch_trace01_5 ch_trace01_6_rl 0.00606066
LCH_trace01_6 ch_trace01_6_rl ch_trace01_6 0.819664n
CCH_trace01_6 ch_trace01_6 0 0.0546267p
RCH_trace01_7 ch_trace01_6 ch_trace01_7_rl 0.00606066
LCH_trace01_7 ch_trace01_7_rl ch_trace01_7 0.819664n
CCH_trace01_7 ch_trace01_7 0 0.0546267p
RCH_trace01_8 ch_trace01_7 ch_trace01_8_rl 0.00606066
LCH_trace01_8 ch_trace01_8_rl ch_trace01_8 0.819664n
CCH_trace01_8 ch_trace01_8 0 0.0546267p
RCH_trace01_9 ch_trace01_8 ch_trace01_9_rl 0.00606066
LCH_trace01_9 ch_trace01_9_rl ch_trace01_9 0.819664n
CCH_trace01_9 ch_trace01_9 0 0.0546267p
RCH_trace01_10 ch_trace01_9 ch_trace01_10_rl 0.00606066
LCH_trace01_10 ch_trace01_10_rl ch_trace01_10 0.819664n
CCH_trace01_10 ch_trace01_10 0 0.0546267p
RCH_trace01_11 ch_trace01_10 ch_trace01_11_rl 0.00606066
LCH_trace01_11 ch_trace01_11_rl ch_trace01_11 0.819664n
CCH_trace01_11 ch_trace01_11 0 0.0546267p
RCH_trace01_12 ch_trace01_11 ch_trace01_12_rl 0.00606066
LCH_trace01_12 ch_trace01_12_rl ch_trace01_12 0.819664n
CCH_trace01_12 ch_trace01_12 0 0.0546267p
RCH_trace01_13 ch_trace01_12 ch_trace01_13_rl 0.00606066
LCH_trace01_13 ch_trace01_13_rl ch_trace01_13 0.819664n
CCH_trace01_13 ch_trace01_13 0 0.0546267p
RCH_trace01_14 ch_trace01_13 ch_trace01_14_rl 0.00606066
LCH_trace01_14 ch_trace01_14_rl ch_trace01_14 0.819664n
CCH_trace01_14 ch_trace01_14 0 0.0546267p
RCH_trace01_15 ch_trace01_14 ch_trace01_15_rl 0.00606066
LCH_trace01_15 ch_trace01_15_rl ch_trace01_15 0.819664n
CCH_trace01_15 ch_trace01_15 0 0.0546267p
RCH_trace01_16 ch_trace01_15 ch_trace01_16_rl 0.00606066
LCH_trace01_16 ch_trace01_16_rl ch_trace01_16 0.819664n
CCH_trace01_16 ch_trace01_16 0 0.0546267p
RCH_trace01_17 ch_trace01_16 ch_trace01_17_rl 0.00606066
LCH_trace01_17 ch_trace01_17_rl ch_trace01_17 0.819664n
CCH_trace01_17 ch_trace01_17 0 0.0546267p
RCH_trace01_18 ch_trace01_17 ch_trace01_18_rl 0.00606066
LCH_trace01_18 ch_trace01_18_rl ch_trace01_18 0.819664n
CCH_trace01_18 ch_trace01_18 0 0.0546267p
RCH_trace01_19 ch_trace01_18 ch_trace01_19_rl 0.00606066
LCH_trace01_19 ch_trace01_19_rl ch_trace01_19 0.819664n
CCH_trace01_19 ch_trace01_19 0 0.0546267p
RCH_trace01_20 ch_trace01_19 ch_trace01_20_rl 0.00606066
LCH_trace01_20 ch_trace01_20_rl ch_trace01_20 0.819664n
CCH_trace01_20 ch_trace01_20 0 0.0546267p
RCH_trace01_21 ch_trace01_20 ch_trace01_21_rl 0.00606066
LCH_trace01_21 ch_trace01_21_rl ch_trace01_21 0.819664n
CCH_trace01_21 ch_trace01_21 0 0.0546267p
RCH_trace01_22 ch_trace01_21 ch_trace01_22_rl 0.00606066
LCH_trace01_22 ch_trace01_22_rl ch_trace01_22 0.819664n
CCH_trace01_22 ch_trace01_22 0 0.0546267p
RCH_trace01_23 ch_trace01_22 ch_trace01_23_rl 0.00606066
LCH_trace01_23 ch_trace01_23_rl ch_trace01_23 0.819664n
CCH_trace01_23 ch_trace01_23 0 0.0546267p
RCH_trace01_24 ch_trace01_23 ch_trace01_24_rl 0.00606066
LCH_trace01_24 ch_trace01_24_rl ch_trace01_24 0.819664n
CCH_trace01_24 ch_trace01_24 0 0.0546267p
RCH_trace01_25 ch_trace01_24 ch_trace01_25_rl 0.00606066
LCH_trace01_25 ch_trace01_25_rl ch_trace01_25 0.819664n
CCH_trace01_25 ch_trace01_25 0 0.0546267p
RCH_trace01_26 ch_trace01_25 ch_trace01_26_rl 0.00606066
LCH_trace01_26 ch_trace01_26_rl ch_trace01_26 0.819664n
CCH_trace01_26 ch_trace01_26 0 0.0546267p
RCH_trace01_27 ch_trace01_26 ch_trace01_27_rl 0.00606066
LCH_trace01_27 ch_trace01_27_rl ch_trace01_27 0.819664n
CCH_trace01_27 ch_trace01_27 0 0.0546267p
RCH_trace01_28 ch_trace01_27 ch_trace01_28_rl 0.00606066
LCH_trace01_28 ch_trace01_28_rl ch_trace01_28 0.819664n
CCH_trace01_28 ch_trace01_28 0 0.0546267p
RCH_trace01_29 ch_trace01_28 ch_trace01_29_rl 0.00606066
LCH_trace01_29 ch_trace01_29_rl ch_trace01_29 0.819664n
CCH_trace01_29 ch_trace01_29 0 0.0546267p
RCH_trace01_30 ch_trace01_29 ch_trace01_30_rl 0.00606066
LCH_trace01_30 ch_trace01_30_rl ch_trace01_30 0.819664n
CCH_trace01_30 ch_trace01_30 0 0.0546267p
RCH_trace01_31 ch_trace01_30 ch_trace01_31_rl 0.00606066
LCH_trace01_31 ch_trace01_31_rl ch_trace01_31 0.819664n
CCH_trace01_31 ch_trace01_31 0 0.0546267p
RCH_trace01_32 ch_trace01_31 ch_trace01_32_rl 0.00606066
LCH_trace01_32 ch_trace01_32_rl ch_trace01_32 0.819664n
CCH_trace01_32 ch_trace01_32 0 0.0546267p
RCH_trace01_33 ch_trace01_32 ch_trace01_33_rl 0.00606066
LCH_trace01_33 ch_trace01_33_rl ch_trace01_33 0.819664n
CCH_trace01_33 ch_trace01_33 0 0.0546267p
RCH_trace01_34 ch_trace01_33 ch_trace01_34_rl 0.00606066
LCH_trace01_34 ch_trace01_34_rl ch_trace01_34 0.819664n
CCH_trace01_34 ch_trace01_34 0 0.0546267p
RCH_trace01_35 ch_trace01_34 ch_trace01_35_rl 0.00606066
LCH_trace01_35 ch_trace01_35_rl ch_trace01_35 0.819664n
CCH_trace01_35 ch_trace01_35 0 0.0546267p
RCH_trace01_36 ch_trace01_35 ch_trace01_36_rl 0.00606066
LCH_trace01_36 ch_trace01_36_rl ch_trace01_36 0.819664n
CCH_trace01_36 ch_trace01_36 0 0.0546267p
RCH_trace01_37 ch_trace01_36 ch_trace01_37_rl 0.00606066
LCH_trace01_37 ch_trace01_37_rl ch_trace01_37 0.819664n
CCH_trace01_37 ch_trace01_37 0 0.0546267p
RCH_trace01_38 ch_trace01_37 ch_trace01_38_rl 0.00606066
LCH_trace01_38 ch_trace01_38_rl ch_trace01_38 0.819664n
CCH_trace01_38 ch_trace01_38 0 0.0546267p
RCH_trace01_39 ch_trace01_38 ch_trace01_39_rl 0.00606066
LCH_trace01_39 ch_trace01_39_rl ch_trace01_39 0.819664n
CCH_trace01_39 ch_trace01_39 0 0.0546267p
RCH_trace01_40 ch_trace01_39 ch_trace01_40_rl 0.00606066
LCH_trace01_40 ch_trace01_40_rl ch_trace01_40 0.819664n
CCH_trace01_40 ch_trace01_40 0 0.0546267p
RCH_trace01_41 ch_trace01_40 ch_trace01_41_rl 0.00606066
LCH_trace01_41 ch_trace01_41_rl ch_trace01_41 0.819664n
CCH_trace01_41 ch_trace01_41 0 0.0546267p
RCH_trace01_42 ch_trace01_41 ch_trace01_42_rl 0.00606066
LCH_trace01_42 ch_trace01_42_rl ch_trace01_42 0.819664n
CCH_trace01_42 ch_trace01_42 0 0.0546267p
RCH_trace01_43 ch_trace01_42 ch_trace01_43_rl 0.00606066
LCH_trace01_43 ch_trace01_43_rl ch_trace01_43 0.819664n
CCH_trace01_43 ch_trace01_43 0 0.0546267p
RCH_trace01_44 ch_trace01_43 ch_trace01_44_rl 0.00606066
LCH_trace01_44 ch_trace01_44_rl ch_trace01_44 0.819664n
CCH_trace01_44 ch_trace01_44 0 0.0546267p
RCH_trace01_45 ch_trace01_44 ch_trace01_45_rl 0.00606066
LCH_trace01_45 ch_trace01_45_rl ch_trace01_45 0.819664n
CCH_trace01_45 ch_trace01_45 0 0.0546267p
RCH_trace01_46 ch_trace01_45 ch_trace01_46_rl 0.00606066
LCH_trace01_46 ch_trace01_46_rl ch_trace01_46 0.819664n
CCH_trace01_46 ch_trace01_46 0 0.0546267p
RCH_trace01_47 ch_trace01_46 ch_trace01_47_rl 0.00606066
LCH_trace01_47 ch_trace01_47_rl ch_trace01_47 0.819664n
CCH_trace01_47 ch_trace01_47 0 0.0546267p
RCH_trace01_48 ch_trace01_47 ch_trace01_48_rl 0.00606066
LCH_trace01_48 ch_trace01_48_rl ch_trace01_48 0.819664n
CCH_trace01_48 ch_trace01_48 0 0.0546267p
RCH_trace01_49 ch_trace01_48 ch_trace01_49_rl 0.00606066
LCH_trace01_49 ch_trace01_49_rl ch_trace01_49 0.819664n
CCH_trace01_49 ch_trace01_49 0 0.0546267p
RCH_trace01_50 ch_trace01_49 ch_trace01_50_rl 0.00606066
LCH_trace01_50 ch_trace01_50_rl ch_trace01_50 0.819664n
CCH_trace01_50 ch_trace01_50 0 0.0546267p
RCH_trace01_51 ch_trace01_50 ch_trace01_51_rl 0.00606066
LCH_trace01_51 ch_trace01_51_rl ch_trace01_51 0.819664n
CCH_trace01_51 ch_trace01_51 0 0.0546267p
RCH_trace01_52 ch_trace01_51 ch_trace01_52_rl 0.00606066
LCH_trace01_52 ch_trace01_52_rl ch_trace01_52 0.819664n
CCH_trace01_52 ch_trace01_52 0 0.0546267p
RCH_trace01_53 ch_trace01_52 ch_trace01_53_rl 0.00606066
LCH_trace01_53 ch_trace01_53_rl ch_trace01_53 0.819664n
CCH_trace01_53 ch_trace01_53 0 0.0546267p
RCH_trace01_54 ch_trace01_53 ch_trace01_54_rl 0.00606066
LCH_trace01_54 ch_trace01_54_rl ch_trace01_54 0.819664n
CCH_trace01_54 ch_trace01_54 0 0.0546267p
RCH_trace01_55 ch_trace01_54 ch_trace01_55_rl 0.00606066
LCH_trace01_55 ch_trace01_55_rl ch_trace01_55 0.819664n
CCH_trace01_55 ch_trace01_55 0 0.0546267p
RCH_trace01_56 ch_trace01_55 ch_trace01_56_rl 0.00606066
LCH_trace01_56 ch_trace01_56_rl ch_trace01_56 0.819664n
CCH_trace01_56 ch_trace01_56 0 0.0546267p
RCH_trace01_57 ch_trace01_56 ch_trace01_57_rl 0.00606066
LCH_trace01_57 ch_trace01_57_rl ch_trace01_57 0.819664n
CCH_trace01_57 ch_trace01_57 0 0.0546267p
RCH_trace01_58 ch_trace01_57 ch_trace01_58_rl 0.00606066
LCH_trace01_58 ch_trace01_58_rl ch_trace01_58 0.819664n
CCH_trace01_58 ch_trace01_58 0 0.0546267p
RCH_trace01_59 ch_trace01_58 ch_trace01_59_rl 0.00606066
LCH_trace01_59 ch_trace01_59_rl ch_trace01_59 0.819664n
CCH_trace01_59 ch_trace01_59 0 0.0546267p
RCH_trace01_60 ch_trace01_59 ch_trace01_60_rl 0.00606066
LCH_trace01_60 ch_trace01_60_rl ch_trace01_60 0.819664n
CCH_trace01_60 ch_trace01_60 0 0.0546267p
RCH_trace01_61 ch_trace01_60 ch_trace01_61_rl 0.00606066
LCH_trace01_61 ch_trace01_61_rl ch_trace01_61 0.819664n
CCH_trace01_61 ch_trace01_61 0 0.0546267p
RCH_trace01_62 ch_trace01_61 ch_trace01_62_rl 0.00606066
LCH_trace01_62 ch_trace01_62_rl ch_trace01_62 0.819664n
CCH_trace01_62 ch_trace01_62 0 0.0546267p
RCH_trace01_63 ch_trace01_62 ch_trace01_63_rl 0.00606066
LCH_trace01_63 ch_trace01_63_rl ch_trace01_63 0.819664n
CCH_trace01_63 ch_trace01_63 0 0.0546267p
RCH_trace01_64 ch_trace01_63 ch_trace01_64_rl 0.00606066
LCH_trace01_64 ch_trace01_64_rl ch_trace01_64 0.819664n
CCH_trace01_64 ch_trace01_64 0 0.0546267p
RCH_trace01_65 ch_trace01_64 ch_trace01_65_rl 0.00606066
LCH_trace01_65 ch_trace01_65_rl ch_trace01_65 0.819664n
CCH_trace01_65 ch_trace01_65 0 0.0546267p
RCH_trace01_66 ch_trace01_65 ch_trace01_66_rl 0.00606066
LCH_trace01_66 ch_trace01_66_rl ch_trace01_66 0.819664n
CCH_trace01_66 ch_trace01_66 0 0.0546267p
RCH_trace01_67 ch_trace01_66 ch_trace01_67_rl 0.00606066
LCH_trace01_67 ch_trace01_67_rl ch_trace01_67 0.819664n
CCH_trace01_67 ch_trace01_67 0 0.0546267p
RCH_trace01_68 ch_trace01_67 ch_trace01_68_rl 0.00606066
LCH_trace01_68 ch_trace01_68_rl ch_trace01_68 0.819664n
CCH_trace01_68 ch_trace01_68 0 0.0546267p
RCH_trace01_69 ch_trace01_68 ch_trace01_69_rl 0.00606066
LCH_trace01_69 ch_trace01_69_rl ch_trace01_69 0.819664n
CCH_trace01_69 ch_trace01_69 0 0.0546267p
RCH_trace01_70 ch_trace01_69 ch_trace01_70_rl 0.00606066
LCH_trace01_70 ch_trace01_70_rl ch_trace01_70 0.819664n
CCH_trace01_70 ch_trace01_70 0 0.0546267p
RCH_trace01_71 ch_trace01_70 ch_trace01_71_rl 0.00606066
LCH_trace01_71 ch_trace01_71_rl ch_trace01_71 0.819664n
CCH_trace01_71 ch_trace01_71 0 0.0546267p
RCH_trace01_72 ch_trace01_71 ch_trace01_72_rl 0.00606066
LCH_trace01_72 ch_trace01_72_rl ch_trace01_72 0.819664n
CCH_trace01_72 ch_trace01_72 0 0.0546267p
RCH_trace01_73 ch_trace01_72 ch_trace01_73_rl 0.00606066
LCH_trace01_73 ch_trace01_73_rl ch_trace01_73 0.819664n
CCH_trace01_73 ch_trace01_73 0 0.0546267p
RCH_trace01_74 ch_trace01_73 ch_trace01_74_rl 0.00606066
LCH_trace01_74 ch_trace01_74_rl ch_trace01_74 0.819664n
CCH_trace01_74 ch_trace01_74 0 0.0546267p
RCH_trace01_75 ch_trace01_74 ch_trace01_75_rl 0.00606066
LCH_trace01_75 ch_trace01_75_rl ch_trace01_75 0.819664n
CCH_trace01_75 ch_trace01_75 0 0.0546267p
RCH_trace01_76 ch_trace01_75 ch_trace01_76_rl 0.00606066
LCH_trace01_76 ch_trace01_76_rl ch_trace01_76 0.819664n
CCH_trace01_76 ch_trace01_76 0 0.0546267p
RCH_trace01_77 ch_trace01_76 ch_trace01_77_rl 0.00606066
LCH_trace01_77 ch_trace01_77_rl ch_trace01_77 0.819664n
CCH_trace01_77 ch_trace01_77 0 0.0546267p
RCH_trace01_78 ch_trace01_77 ch_trace01_78_rl 0.00606066
LCH_trace01_78 ch_trace01_78_rl ch_trace01_78 0.819664n
CCH_trace01_78 ch_trace01_78 0 0.0546267p
RCH_trace01_79 ch_trace01_78 ch_trace01_79_rl 0.00606066
LCH_trace01_79 ch_trace01_79_rl ch_trace01_79 0.819664n
CCH_trace01_79 ch_trace01_79 0 0.0546267p
RCH_trace01_80 ch_trace01_79 ch_trace01_80_rl 0.00606066
LCH_trace01_80 ch_trace01_80_rl pad_trace01 0.819664n
CCH_trace01_80 pad_trace01 0 0.0546267p
RLOAD_trace01 pad_trace01 0 1160

* Wmodel_Trace02::Sig: Ro/Lo/Go/Co baseline, Rs=0.00126077 ignored, Gd=0 ignored
Xtrace02 src_trace02 in_dig en_sig vdd 0 I3C_TX_0p125mA_tx_OutputInput_Typical
RCH_trace02_1 src_trace02 ch_trace02_1_rl 0.00606066
LCH_trace02_1 ch_trace02_1_rl ch_trace02_1 0.819664n
CCH_trace02_1 ch_trace02_1 0 0.0546267p
RCH_trace02_2 ch_trace02_1 ch_trace02_2_rl 0.00606066
LCH_trace02_2 ch_trace02_2_rl ch_trace02_2 0.819664n
CCH_trace02_2 ch_trace02_2 0 0.0546267p
RCH_trace02_3 ch_trace02_2 ch_trace02_3_rl 0.00606066
LCH_trace02_3 ch_trace02_3_rl ch_trace02_3 0.819664n
CCH_trace02_3 ch_trace02_3 0 0.0546267p
RCH_trace02_4 ch_trace02_3 ch_trace02_4_rl 0.00606066
LCH_trace02_4 ch_trace02_4_rl ch_trace02_4 0.819664n
CCH_trace02_4 ch_trace02_4 0 0.0546267p
RCH_trace02_5 ch_trace02_4 ch_trace02_5_rl 0.00606066
LCH_trace02_5 ch_trace02_5_rl ch_trace02_5 0.819664n
CCH_trace02_5 ch_trace02_5 0 0.0546267p
RCH_trace02_6 ch_trace02_5 ch_trace02_6_rl 0.00606066
LCH_trace02_6 ch_trace02_6_rl ch_trace02_6 0.819664n
CCH_trace02_6 ch_trace02_6 0 0.0546267p
RCH_trace02_7 ch_trace02_6 ch_trace02_7_rl 0.00606066
LCH_trace02_7 ch_trace02_7_rl ch_trace02_7 0.819664n
CCH_trace02_7 ch_trace02_7 0 0.0546267p
RCH_trace02_8 ch_trace02_7 ch_trace02_8_rl 0.00606066
LCH_trace02_8 ch_trace02_8_rl ch_trace02_8 0.819664n
CCH_trace02_8 ch_trace02_8 0 0.0546267p
RCH_trace02_9 ch_trace02_8 ch_trace02_9_rl 0.00606066
LCH_trace02_9 ch_trace02_9_rl ch_trace02_9 0.819664n
CCH_trace02_9 ch_trace02_9 0 0.0546267p
RCH_trace02_10 ch_trace02_9 ch_trace02_10_rl 0.00606066
LCH_trace02_10 ch_trace02_10_rl ch_trace02_10 0.819664n
CCH_trace02_10 ch_trace02_10 0 0.0546267p
RCH_trace02_11 ch_trace02_10 ch_trace02_11_rl 0.00606066
LCH_trace02_11 ch_trace02_11_rl ch_trace02_11 0.819664n
CCH_trace02_11 ch_trace02_11 0 0.0546267p
RCH_trace02_12 ch_trace02_11 ch_trace02_12_rl 0.00606066
LCH_trace02_12 ch_trace02_12_rl ch_trace02_12 0.819664n
CCH_trace02_12 ch_trace02_12 0 0.0546267p
RCH_trace02_13 ch_trace02_12 ch_trace02_13_rl 0.00606066
LCH_trace02_13 ch_trace02_13_rl ch_trace02_13 0.819664n
CCH_trace02_13 ch_trace02_13 0 0.0546267p
RCH_trace02_14 ch_trace02_13 ch_trace02_14_rl 0.00606066
LCH_trace02_14 ch_trace02_14_rl ch_trace02_14 0.819664n
CCH_trace02_14 ch_trace02_14 0 0.0546267p
RCH_trace02_15 ch_trace02_14 ch_trace02_15_rl 0.00606066
LCH_trace02_15 ch_trace02_15_rl ch_trace02_15 0.819664n
CCH_trace02_15 ch_trace02_15 0 0.0546267p
RCH_trace02_16 ch_trace02_15 ch_trace02_16_rl 0.00606066
LCH_trace02_16 ch_trace02_16_rl ch_trace02_16 0.819664n
CCH_trace02_16 ch_trace02_16 0 0.0546267p
RCH_trace02_17 ch_trace02_16 ch_trace02_17_rl 0.00606066
LCH_trace02_17 ch_trace02_17_rl ch_trace02_17 0.819664n
CCH_trace02_17 ch_trace02_17 0 0.0546267p
RCH_trace02_18 ch_trace02_17 ch_trace02_18_rl 0.00606066
LCH_trace02_18 ch_trace02_18_rl ch_trace02_18 0.819664n
CCH_trace02_18 ch_trace02_18 0 0.0546267p
RCH_trace02_19 ch_trace02_18 ch_trace02_19_rl 0.00606066
LCH_trace02_19 ch_trace02_19_rl ch_trace02_19 0.819664n
CCH_trace02_19 ch_trace02_19 0 0.0546267p
RCH_trace02_20 ch_trace02_19 ch_trace02_20_rl 0.00606066
LCH_trace02_20 ch_trace02_20_rl ch_trace02_20 0.819664n
CCH_trace02_20 ch_trace02_20 0 0.0546267p
RCH_trace02_21 ch_trace02_20 ch_trace02_21_rl 0.00606066
LCH_trace02_21 ch_trace02_21_rl ch_trace02_21 0.819664n
CCH_trace02_21 ch_trace02_21 0 0.0546267p
RCH_trace02_22 ch_trace02_21 ch_trace02_22_rl 0.00606066
LCH_trace02_22 ch_trace02_22_rl ch_trace02_22 0.819664n
CCH_trace02_22 ch_trace02_22 0 0.0546267p
RCH_trace02_23 ch_trace02_22 ch_trace02_23_rl 0.00606066
LCH_trace02_23 ch_trace02_23_rl ch_trace02_23 0.819664n
CCH_trace02_23 ch_trace02_23 0 0.0546267p
RCH_trace02_24 ch_trace02_23 ch_trace02_24_rl 0.00606066
LCH_trace02_24 ch_trace02_24_rl ch_trace02_24 0.819664n
CCH_trace02_24 ch_trace02_24 0 0.0546267p
RCH_trace02_25 ch_trace02_24 ch_trace02_25_rl 0.00606066
LCH_trace02_25 ch_trace02_25_rl ch_trace02_25 0.819664n
CCH_trace02_25 ch_trace02_25 0 0.0546267p
RCH_trace02_26 ch_trace02_25 ch_trace02_26_rl 0.00606066
LCH_trace02_26 ch_trace02_26_rl ch_trace02_26 0.819664n
CCH_trace02_26 ch_trace02_26 0 0.0546267p
RCH_trace02_27 ch_trace02_26 ch_trace02_27_rl 0.00606066
LCH_trace02_27 ch_trace02_27_rl ch_trace02_27 0.819664n
CCH_trace02_27 ch_trace02_27 0 0.0546267p
RCH_trace02_28 ch_trace02_27 ch_trace02_28_rl 0.00606066
LCH_trace02_28 ch_trace02_28_rl ch_trace02_28 0.819664n
CCH_trace02_28 ch_trace02_28 0 0.0546267p
RCH_trace02_29 ch_trace02_28 ch_trace02_29_rl 0.00606066
LCH_trace02_29 ch_trace02_29_rl ch_trace02_29 0.819664n
CCH_trace02_29 ch_trace02_29 0 0.0546267p
RCH_trace02_30 ch_trace02_29 ch_trace02_30_rl 0.00606066
LCH_trace02_30 ch_trace02_30_rl ch_trace02_30 0.819664n
CCH_trace02_30 ch_trace02_30 0 0.0546267p
RCH_trace02_31 ch_trace02_30 ch_trace02_31_rl 0.00606066
LCH_trace02_31 ch_trace02_31_rl ch_trace02_31 0.819664n
CCH_trace02_31 ch_trace02_31 0 0.0546267p
RCH_trace02_32 ch_trace02_31 ch_trace02_32_rl 0.00606066
LCH_trace02_32 ch_trace02_32_rl ch_trace02_32 0.819664n
CCH_trace02_32 ch_trace02_32 0 0.0546267p
RCH_trace02_33 ch_trace02_32 ch_trace02_33_rl 0.00606066
LCH_trace02_33 ch_trace02_33_rl ch_trace02_33 0.819664n
CCH_trace02_33 ch_trace02_33 0 0.0546267p
RCH_trace02_34 ch_trace02_33 ch_trace02_34_rl 0.00606066
LCH_trace02_34 ch_trace02_34_rl ch_trace02_34 0.819664n
CCH_trace02_34 ch_trace02_34 0 0.0546267p
RCH_trace02_35 ch_trace02_34 ch_trace02_35_rl 0.00606066
LCH_trace02_35 ch_trace02_35_rl ch_trace02_35 0.819664n
CCH_trace02_35 ch_trace02_35 0 0.0546267p
RCH_trace02_36 ch_trace02_35 ch_trace02_36_rl 0.00606066
LCH_trace02_36 ch_trace02_36_rl ch_trace02_36 0.819664n
CCH_trace02_36 ch_trace02_36 0 0.0546267p
RCH_trace02_37 ch_trace02_36 ch_trace02_37_rl 0.00606066
LCH_trace02_37 ch_trace02_37_rl ch_trace02_37 0.819664n
CCH_trace02_37 ch_trace02_37 0 0.0546267p
RCH_trace02_38 ch_trace02_37 ch_trace02_38_rl 0.00606066
LCH_trace02_38 ch_trace02_38_rl ch_trace02_38 0.819664n
CCH_trace02_38 ch_trace02_38 0 0.0546267p
RCH_trace02_39 ch_trace02_38 ch_trace02_39_rl 0.00606066
LCH_trace02_39 ch_trace02_39_rl ch_trace02_39 0.819664n
CCH_trace02_39 ch_trace02_39 0 0.0546267p
RCH_trace02_40 ch_trace02_39 ch_trace02_40_rl 0.00606066
LCH_trace02_40 ch_trace02_40_rl ch_trace02_40 0.819664n
CCH_trace02_40 ch_trace02_40 0 0.0546267p
RCH_trace02_41 ch_trace02_40 ch_trace02_41_rl 0.00606066
LCH_trace02_41 ch_trace02_41_rl ch_trace02_41 0.819664n
CCH_trace02_41 ch_trace02_41 0 0.0546267p
RCH_trace02_42 ch_trace02_41 ch_trace02_42_rl 0.00606066
LCH_trace02_42 ch_trace02_42_rl ch_trace02_42 0.819664n
CCH_trace02_42 ch_trace02_42 0 0.0546267p
RCH_trace02_43 ch_trace02_42 ch_trace02_43_rl 0.00606066
LCH_trace02_43 ch_trace02_43_rl ch_trace02_43 0.819664n
CCH_trace02_43 ch_trace02_43 0 0.0546267p
RCH_trace02_44 ch_trace02_43 ch_trace02_44_rl 0.00606066
LCH_trace02_44 ch_trace02_44_rl ch_trace02_44 0.819664n
CCH_trace02_44 ch_trace02_44 0 0.0546267p
RCH_trace02_45 ch_trace02_44 ch_trace02_45_rl 0.00606066
LCH_trace02_45 ch_trace02_45_rl ch_trace02_45 0.819664n
CCH_trace02_45 ch_trace02_45 0 0.0546267p
RCH_trace02_46 ch_trace02_45 ch_trace02_46_rl 0.00606066
LCH_trace02_46 ch_trace02_46_rl ch_trace02_46 0.819664n
CCH_trace02_46 ch_trace02_46 0 0.0546267p
RCH_trace02_47 ch_trace02_46 ch_trace02_47_rl 0.00606066
LCH_trace02_47 ch_trace02_47_rl ch_trace02_47 0.819664n
CCH_trace02_47 ch_trace02_47 0 0.0546267p
RCH_trace02_48 ch_trace02_47 ch_trace02_48_rl 0.00606066
LCH_trace02_48 ch_trace02_48_rl ch_trace02_48 0.819664n
CCH_trace02_48 ch_trace02_48 0 0.0546267p
RCH_trace02_49 ch_trace02_48 ch_trace02_49_rl 0.00606066
LCH_trace02_49 ch_trace02_49_rl ch_trace02_49 0.819664n
CCH_trace02_49 ch_trace02_49 0 0.0546267p
RCH_trace02_50 ch_trace02_49 ch_trace02_50_rl 0.00606066
LCH_trace02_50 ch_trace02_50_rl ch_trace02_50 0.819664n
CCH_trace02_50 ch_trace02_50 0 0.0546267p
RCH_trace02_51 ch_trace02_50 ch_trace02_51_rl 0.00606066
LCH_trace02_51 ch_trace02_51_rl ch_trace02_51 0.819664n
CCH_trace02_51 ch_trace02_51 0 0.0546267p
RCH_trace02_52 ch_trace02_51 ch_trace02_52_rl 0.00606066
LCH_trace02_52 ch_trace02_52_rl ch_trace02_52 0.819664n
CCH_trace02_52 ch_trace02_52 0 0.0546267p
RCH_trace02_53 ch_trace02_52 ch_trace02_53_rl 0.00606066
LCH_trace02_53 ch_trace02_53_rl ch_trace02_53 0.819664n
CCH_trace02_53 ch_trace02_53 0 0.0546267p
RCH_trace02_54 ch_trace02_53 ch_trace02_54_rl 0.00606066
LCH_trace02_54 ch_trace02_54_rl ch_trace02_54 0.819664n
CCH_trace02_54 ch_trace02_54 0 0.0546267p
RCH_trace02_55 ch_trace02_54 ch_trace02_55_rl 0.00606066
LCH_trace02_55 ch_trace02_55_rl ch_trace02_55 0.819664n
CCH_trace02_55 ch_trace02_55 0 0.0546267p
RCH_trace02_56 ch_trace02_55 ch_trace02_56_rl 0.00606066
LCH_trace02_56 ch_trace02_56_rl ch_trace02_56 0.819664n
CCH_trace02_56 ch_trace02_56 0 0.0546267p
RCH_trace02_57 ch_trace02_56 ch_trace02_57_rl 0.00606066
LCH_trace02_57 ch_trace02_57_rl ch_trace02_57 0.819664n
CCH_trace02_57 ch_trace02_57 0 0.0546267p
RCH_trace02_58 ch_trace02_57 ch_trace02_58_rl 0.00606066
LCH_trace02_58 ch_trace02_58_rl ch_trace02_58 0.819664n
CCH_trace02_58 ch_trace02_58 0 0.0546267p
RCH_trace02_59 ch_trace02_58 ch_trace02_59_rl 0.00606066
LCH_trace02_59 ch_trace02_59_rl ch_trace02_59 0.819664n
CCH_trace02_59 ch_trace02_59 0 0.0546267p
RCH_trace02_60 ch_trace02_59 ch_trace02_60_rl 0.00606066
LCH_trace02_60 ch_trace02_60_rl ch_trace02_60 0.819664n
CCH_trace02_60 ch_trace02_60 0 0.0546267p
RCH_trace02_61 ch_trace02_60 ch_trace02_61_rl 0.00606066
LCH_trace02_61 ch_trace02_61_rl ch_trace02_61 0.819664n
CCH_trace02_61 ch_trace02_61 0 0.0546267p
RCH_trace02_62 ch_trace02_61 ch_trace02_62_rl 0.00606066
LCH_trace02_62 ch_trace02_62_rl ch_trace02_62 0.819664n
CCH_trace02_62 ch_trace02_62 0 0.0546267p
RCH_trace02_63 ch_trace02_62 ch_trace02_63_rl 0.00606066
LCH_trace02_63 ch_trace02_63_rl ch_trace02_63 0.819664n
CCH_trace02_63 ch_trace02_63 0 0.0546267p
RCH_trace02_64 ch_trace02_63 ch_trace02_64_rl 0.00606066
LCH_trace02_64 ch_trace02_64_rl ch_trace02_64 0.819664n
CCH_trace02_64 ch_trace02_64 0 0.0546267p
RCH_trace02_65 ch_trace02_64 ch_trace02_65_rl 0.00606066
LCH_trace02_65 ch_trace02_65_rl ch_trace02_65 0.819664n
CCH_trace02_65 ch_trace02_65 0 0.0546267p
RCH_trace02_66 ch_trace02_65 ch_trace02_66_rl 0.00606066
LCH_trace02_66 ch_trace02_66_rl ch_trace02_66 0.819664n
CCH_trace02_66 ch_trace02_66 0 0.0546267p
RCH_trace02_67 ch_trace02_66 ch_trace02_67_rl 0.00606066
LCH_trace02_67 ch_trace02_67_rl ch_trace02_67 0.819664n
CCH_trace02_67 ch_trace02_67 0 0.0546267p
RCH_trace02_68 ch_trace02_67 ch_trace02_68_rl 0.00606066
LCH_trace02_68 ch_trace02_68_rl ch_trace02_68 0.819664n
CCH_trace02_68 ch_trace02_68 0 0.0546267p
RCH_trace02_69 ch_trace02_68 ch_trace02_69_rl 0.00606066
LCH_trace02_69 ch_trace02_69_rl ch_trace02_69 0.819664n
CCH_trace02_69 ch_trace02_69 0 0.0546267p
RCH_trace02_70 ch_trace02_69 ch_trace02_70_rl 0.00606066
LCH_trace02_70 ch_trace02_70_rl ch_trace02_70 0.819664n
CCH_trace02_70 ch_trace02_70 0 0.0546267p
RCH_trace02_71 ch_trace02_70 ch_trace02_71_rl 0.00606066
LCH_trace02_71 ch_trace02_71_rl ch_trace02_71 0.819664n
CCH_trace02_71 ch_trace02_71 0 0.0546267p
RCH_trace02_72 ch_trace02_71 ch_trace02_72_rl 0.00606066
LCH_trace02_72 ch_trace02_72_rl ch_trace02_72 0.819664n
CCH_trace02_72 ch_trace02_72 0 0.0546267p
RCH_trace02_73 ch_trace02_72 ch_trace02_73_rl 0.00606066
LCH_trace02_73 ch_trace02_73_rl ch_trace02_73 0.819664n
CCH_trace02_73 ch_trace02_73 0 0.0546267p
RCH_trace02_74 ch_trace02_73 ch_trace02_74_rl 0.00606066
LCH_trace02_74 ch_trace02_74_rl ch_trace02_74 0.819664n
CCH_trace02_74 ch_trace02_74 0 0.0546267p
RCH_trace02_75 ch_trace02_74 ch_trace02_75_rl 0.00606066
LCH_trace02_75 ch_trace02_75_rl ch_trace02_75 0.819664n
CCH_trace02_75 ch_trace02_75 0 0.0546267p
RCH_trace02_76 ch_trace02_75 ch_trace02_76_rl 0.00606066
LCH_trace02_76 ch_trace02_76_rl ch_trace02_76 0.819664n
CCH_trace02_76 ch_trace02_76 0 0.0546267p
RCH_trace02_77 ch_trace02_76 ch_trace02_77_rl 0.00606066
LCH_trace02_77 ch_trace02_77_rl ch_trace02_77 0.819664n
CCH_trace02_77 ch_trace02_77 0 0.0546267p
RCH_trace02_78 ch_trace02_77 ch_trace02_78_rl 0.00606066
LCH_trace02_78 ch_trace02_78_rl ch_trace02_78 0.819664n
CCH_trace02_78 ch_trace02_78 0 0.0546267p
RCH_trace02_79 ch_trace02_78 ch_trace02_79_rl 0.00606066
LCH_trace02_79 ch_trace02_79_rl ch_trace02_79 0.819664n
CCH_trace02_79 ch_trace02_79 0 0.0546267p
RCH_trace02_80 ch_trace02_79 ch_trace02_80_rl 0.00606066
LCH_trace02_80 ch_trace02_80_rl pad_trace02 0.819664n
CCH_trace02_80 pad_trace02 0 0.0546267p
RLOAD_trace02 pad_trace02 0 1160

* Wmodel_Trace03::Sig: Ro/Lo/Go/Co baseline, Rs=0.0017154 ignored, Gd=0 ignored
Xtrace03 src_trace03 in_dig en_sig vdd 0 I3C_TX_0p125mA_tx_OutputInput_Typical
RCH_trace03_1 src_trace03 ch_trace03_1_rl 0.00606066
LCH_trace03_1 ch_trace03_1_rl ch_trace03_1 0.451504n
CCH_trace03_1 ch_trace03_1 0 0.103795p
RCH_trace03_2 ch_trace03_1 ch_trace03_2_rl 0.00606066
LCH_trace03_2 ch_trace03_2_rl ch_trace03_2 0.451504n
CCH_trace03_2 ch_trace03_2 0 0.103795p
RCH_trace03_3 ch_trace03_2 ch_trace03_3_rl 0.00606066
LCH_trace03_3 ch_trace03_3_rl ch_trace03_3 0.451504n
CCH_trace03_3 ch_trace03_3 0 0.103795p
RCH_trace03_4 ch_trace03_3 ch_trace03_4_rl 0.00606066
LCH_trace03_4 ch_trace03_4_rl ch_trace03_4 0.451504n
CCH_trace03_4 ch_trace03_4 0 0.103795p
RCH_trace03_5 ch_trace03_4 ch_trace03_5_rl 0.00606066
LCH_trace03_5 ch_trace03_5_rl ch_trace03_5 0.451504n
CCH_trace03_5 ch_trace03_5 0 0.103795p
RCH_trace03_6 ch_trace03_5 ch_trace03_6_rl 0.00606066
LCH_trace03_6 ch_trace03_6_rl ch_trace03_6 0.451504n
CCH_trace03_6 ch_trace03_6 0 0.103795p
RCH_trace03_7 ch_trace03_6 ch_trace03_7_rl 0.00606066
LCH_trace03_7 ch_trace03_7_rl ch_trace03_7 0.451504n
CCH_trace03_7 ch_trace03_7 0 0.103795p
RCH_trace03_8 ch_trace03_7 ch_trace03_8_rl 0.00606066
LCH_trace03_8 ch_trace03_8_rl ch_trace03_8 0.451504n
CCH_trace03_8 ch_trace03_8 0 0.103795p
RCH_trace03_9 ch_trace03_8 ch_trace03_9_rl 0.00606066
LCH_trace03_9 ch_trace03_9_rl ch_trace03_9 0.451504n
CCH_trace03_9 ch_trace03_9 0 0.103795p
RCH_trace03_10 ch_trace03_9 ch_trace03_10_rl 0.00606066
LCH_trace03_10 ch_trace03_10_rl ch_trace03_10 0.451504n
CCH_trace03_10 ch_trace03_10 0 0.103795p
RCH_trace03_11 ch_trace03_10 ch_trace03_11_rl 0.00606066
LCH_trace03_11 ch_trace03_11_rl ch_trace03_11 0.451504n
CCH_trace03_11 ch_trace03_11 0 0.103795p
RCH_trace03_12 ch_trace03_11 ch_trace03_12_rl 0.00606066
LCH_trace03_12 ch_trace03_12_rl ch_trace03_12 0.451504n
CCH_trace03_12 ch_trace03_12 0 0.103795p
RCH_trace03_13 ch_trace03_12 ch_trace03_13_rl 0.00606066
LCH_trace03_13 ch_trace03_13_rl ch_trace03_13 0.451504n
CCH_trace03_13 ch_trace03_13 0 0.103795p
RCH_trace03_14 ch_trace03_13 ch_trace03_14_rl 0.00606066
LCH_trace03_14 ch_trace03_14_rl ch_trace03_14 0.451504n
CCH_trace03_14 ch_trace03_14 0 0.103795p
RCH_trace03_15 ch_trace03_14 ch_trace03_15_rl 0.00606066
LCH_trace03_15 ch_trace03_15_rl ch_trace03_15 0.451504n
CCH_trace03_15 ch_trace03_15 0 0.103795p
RCH_trace03_16 ch_trace03_15 ch_trace03_16_rl 0.00606066
LCH_trace03_16 ch_trace03_16_rl ch_trace03_16 0.451504n
CCH_trace03_16 ch_trace03_16 0 0.103795p
RCH_trace03_17 ch_trace03_16 ch_trace03_17_rl 0.00606066
LCH_trace03_17 ch_trace03_17_rl ch_trace03_17 0.451504n
CCH_trace03_17 ch_trace03_17 0 0.103795p
RCH_trace03_18 ch_trace03_17 ch_trace03_18_rl 0.00606066
LCH_trace03_18 ch_trace03_18_rl ch_trace03_18 0.451504n
CCH_trace03_18 ch_trace03_18 0 0.103795p
RCH_trace03_19 ch_trace03_18 ch_trace03_19_rl 0.00606066
LCH_trace03_19 ch_trace03_19_rl ch_trace03_19 0.451504n
CCH_trace03_19 ch_trace03_19 0 0.103795p
RCH_trace03_20 ch_trace03_19 ch_trace03_20_rl 0.00606066
LCH_trace03_20 ch_trace03_20_rl ch_trace03_20 0.451504n
CCH_trace03_20 ch_trace03_20 0 0.103795p
RCH_trace03_21 ch_trace03_20 ch_trace03_21_rl 0.00606066
LCH_trace03_21 ch_trace03_21_rl ch_trace03_21 0.451504n
CCH_trace03_21 ch_trace03_21 0 0.103795p
RCH_trace03_22 ch_trace03_21 ch_trace03_22_rl 0.00606066
LCH_trace03_22 ch_trace03_22_rl ch_trace03_22 0.451504n
CCH_trace03_22 ch_trace03_22 0 0.103795p
RCH_trace03_23 ch_trace03_22 ch_trace03_23_rl 0.00606066
LCH_trace03_23 ch_trace03_23_rl ch_trace03_23 0.451504n
CCH_trace03_23 ch_trace03_23 0 0.103795p
RCH_trace03_24 ch_trace03_23 ch_trace03_24_rl 0.00606066
LCH_trace03_24 ch_trace03_24_rl ch_trace03_24 0.451504n
CCH_trace03_24 ch_trace03_24 0 0.103795p
RCH_trace03_25 ch_trace03_24 ch_trace03_25_rl 0.00606066
LCH_trace03_25 ch_trace03_25_rl ch_trace03_25 0.451504n
CCH_trace03_25 ch_trace03_25 0 0.103795p
RCH_trace03_26 ch_trace03_25 ch_trace03_26_rl 0.00606066
LCH_trace03_26 ch_trace03_26_rl ch_trace03_26 0.451504n
CCH_trace03_26 ch_trace03_26 0 0.103795p
RCH_trace03_27 ch_trace03_26 ch_trace03_27_rl 0.00606066
LCH_trace03_27 ch_trace03_27_rl ch_trace03_27 0.451504n
CCH_trace03_27 ch_trace03_27 0 0.103795p
RCH_trace03_28 ch_trace03_27 ch_trace03_28_rl 0.00606066
LCH_trace03_28 ch_trace03_28_rl ch_trace03_28 0.451504n
CCH_trace03_28 ch_trace03_28 0 0.103795p
RCH_trace03_29 ch_trace03_28 ch_trace03_29_rl 0.00606066
LCH_trace03_29 ch_trace03_29_rl ch_trace03_29 0.451504n
CCH_trace03_29 ch_trace03_29 0 0.103795p
RCH_trace03_30 ch_trace03_29 ch_trace03_30_rl 0.00606066
LCH_trace03_30 ch_trace03_30_rl ch_trace03_30 0.451504n
CCH_trace03_30 ch_trace03_30 0 0.103795p
RCH_trace03_31 ch_trace03_30 ch_trace03_31_rl 0.00606066
LCH_trace03_31 ch_trace03_31_rl ch_trace03_31 0.451504n
CCH_trace03_31 ch_trace03_31 0 0.103795p
RCH_trace03_32 ch_trace03_31 ch_trace03_32_rl 0.00606066
LCH_trace03_32 ch_trace03_32_rl ch_trace03_32 0.451504n
CCH_trace03_32 ch_trace03_32 0 0.103795p
RCH_trace03_33 ch_trace03_32 ch_trace03_33_rl 0.00606066
LCH_trace03_33 ch_trace03_33_rl ch_trace03_33 0.451504n
CCH_trace03_33 ch_trace03_33 0 0.103795p
RCH_trace03_34 ch_trace03_33 ch_trace03_34_rl 0.00606066
LCH_trace03_34 ch_trace03_34_rl ch_trace03_34 0.451504n
CCH_trace03_34 ch_trace03_34 0 0.103795p
RCH_trace03_35 ch_trace03_34 ch_trace03_35_rl 0.00606066
LCH_trace03_35 ch_trace03_35_rl ch_trace03_35 0.451504n
CCH_trace03_35 ch_trace03_35 0 0.103795p
RCH_trace03_36 ch_trace03_35 ch_trace03_36_rl 0.00606066
LCH_trace03_36 ch_trace03_36_rl ch_trace03_36 0.451504n
CCH_trace03_36 ch_trace03_36 0 0.103795p
RCH_trace03_37 ch_trace03_36 ch_trace03_37_rl 0.00606066
LCH_trace03_37 ch_trace03_37_rl ch_trace03_37 0.451504n
CCH_trace03_37 ch_trace03_37 0 0.103795p
RCH_trace03_38 ch_trace03_37 ch_trace03_38_rl 0.00606066
LCH_trace03_38 ch_trace03_38_rl ch_trace03_38 0.451504n
CCH_trace03_38 ch_trace03_38 0 0.103795p
RCH_trace03_39 ch_trace03_38 ch_trace03_39_rl 0.00606066
LCH_trace03_39 ch_trace03_39_rl ch_trace03_39 0.451504n
CCH_trace03_39 ch_trace03_39 0 0.103795p
RCH_trace03_40 ch_trace03_39 ch_trace03_40_rl 0.00606066
LCH_trace03_40 ch_trace03_40_rl ch_trace03_40 0.451504n
CCH_trace03_40 ch_trace03_40 0 0.103795p
RCH_trace03_41 ch_trace03_40 ch_trace03_41_rl 0.00606066
LCH_trace03_41 ch_trace03_41_rl ch_trace03_41 0.451504n
CCH_trace03_41 ch_trace03_41 0 0.103795p
RCH_trace03_42 ch_trace03_41 ch_trace03_42_rl 0.00606066
LCH_trace03_42 ch_trace03_42_rl ch_trace03_42 0.451504n
CCH_trace03_42 ch_trace03_42 0 0.103795p
RCH_trace03_43 ch_trace03_42 ch_trace03_43_rl 0.00606066
LCH_trace03_43 ch_trace03_43_rl ch_trace03_43 0.451504n
CCH_trace03_43 ch_trace03_43 0 0.103795p
RCH_trace03_44 ch_trace03_43 ch_trace03_44_rl 0.00606066
LCH_trace03_44 ch_trace03_44_rl ch_trace03_44 0.451504n
CCH_trace03_44 ch_trace03_44 0 0.103795p
RCH_trace03_45 ch_trace03_44 ch_trace03_45_rl 0.00606066
LCH_trace03_45 ch_trace03_45_rl ch_trace03_45 0.451504n
CCH_trace03_45 ch_trace03_45 0 0.103795p
RCH_trace03_46 ch_trace03_45 ch_trace03_46_rl 0.00606066
LCH_trace03_46 ch_trace03_46_rl ch_trace03_46 0.451504n
CCH_trace03_46 ch_trace03_46 0 0.103795p
RCH_trace03_47 ch_trace03_46 ch_trace03_47_rl 0.00606066
LCH_trace03_47 ch_trace03_47_rl ch_trace03_47 0.451504n
CCH_trace03_47 ch_trace03_47 0 0.103795p
RCH_trace03_48 ch_trace03_47 ch_trace03_48_rl 0.00606066
LCH_trace03_48 ch_trace03_48_rl ch_trace03_48 0.451504n
CCH_trace03_48 ch_trace03_48 0 0.103795p
RCH_trace03_49 ch_trace03_48 ch_trace03_49_rl 0.00606066
LCH_trace03_49 ch_trace03_49_rl ch_trace03_49 0.451504n
CCH_trace03_49 ch_trace03_49 0 0.103795p
RCH_trace03_50 ch_trace03_49 ch_trace03_50_rl 0.00606066
LCH_trace03_50 ch_trace03_50_rl ch_trace03_50 0.451504n
CCH_trace03_50 ch_trace03_50 0 0.103795p
RCH_trace03_51 ch_trace03_50 ch_trace03_51_rl 0.00606066
LCH_trace03_51 ch_trace03_51_rl ch_trace03_51 0.451504n
CCH_trace03_51 ch_trace03_51 0 0.103795p
RCH_trace03_52 ch_trace03_51 ch_trace03_52_rl 0.00606066
LCH_trace03_52 ch_trace03_52_rl ch_trace03_52 0.451504n
CCH_trace03_52 ch_trace03_52 0 0.103795p
RCH_trace03_53 ch_trace03_52 ch_trace03_53_rl 0.00606066
LCH_trace03_53 ch_trace03_53_rl ch_trace03_53 0.451504n
CCH_trace03_53 ch_trace03_53 0 0.103795p
RCH_trace03_54 ch_trace03_53 ch_trace03_54_rl 0.00606066
LCH_trace03_54 ch_trace03_54_rl ch_trace03_54 0.451504n
CCH_trace03_54 ch_trace03_54 0 0.103795p
RCH_trace03_55 ch_trace03_54 ch_trace03_55_rl 0.00606066
LCH_trace03_55 ch_trace03_55_rl ch_trace03_55 0.451504n
CCH_trace03_55 ch_trace03_55 0 0.103795p
RCH_trace03_56 ch_trace03_55 ch_trace03_56_rl 0.00606066
LCH_trace03_56 ch_trace03_56_rl ch_trace03_56 0.451504n
CCH_trace03_56 ch_trace03_56 0 0.103795p
RCH_trace03_57 ch_trace03_56 ch_trace03_57_rl 0.00606066
LCH_trace03_57 ch_trace03_57_rl ch_trace03_57 0.451504n
CCH_trace03_57 ch_trace03_57 0 0.103795p
RCH_trace03_58 ch_trace03_57 ch_trace03_58_rl 0.00606066
LCH_trace03_58 ch_trace03_58_rl ch_trace03_58 0.451504n
CCH_trace03_58 ch_trace03_58 0 0.103795p
RCH_trace03_59 ch_trace03_58 ch_trace03_59_rl 0.00606066
LCH_trace03_59 ch_trace03_59_rl ch_trace03_59 0.451504n
CCH_trace03_59 ch_trace03_59 0 0.103795p
RCH_trace03_60 ch_trace03_59 ch_trace03_60_rl 0.00606066
LCH_trace03_60 ch_trace03_60_rl ch_trace03_60 0.451504n
CCH_trace03_60 ch_trace03_60 0 0.103795p
RCH_trace03_61 ch_trace03_60 ch_trace03_61_rl 0.00606066
LCH_trace03_61 ch_trace03_61_rl ch_trace03_61 0.451504n
CCH_trace03_61 ch_trace03_61 0 0.103795p
RCH_trace03_62 ch_trace03_61 ch_trace03_62_rl 0.00606066
LCH_trace03_62 ch_trace03_62_rl ch_trace03_62 0.451504n
CCH_trace03_62 ch_trace03_62 0 0.103795p
RCH_trace03_63 ch_trace03_62 ch_trace03_63_rl 0.00606066
LCH_trace03_63 ch_trace03_63_rl ch_trace03_63 0.451504n
CCH_trace03_63 ch_trace03_63 0 0.103795p
RCH_trace03_64 ch_trace03_63 ch_trace03_64_rl 0.00606066
LCH_trace03_64 ch_trace03_64_rl ch_trace03_64 0.451504n
CCH_trace03_64 ch_trace03_64 0 0.103795p
RCH_trace03_65 ch_trace03_64 ch_trace03_65_rl 0.00606066
LCH_trace03_65 ch_trace03_65_rl ch_trace03_65 0.451504n
CCH_trace03_65 ch_trace03_65 0 0.103795p
RCH_trace03_66 ch_trace03_65 ch_trace03_66_rl 0.00606066
LCH_trace03_66 ch_trace03_66_rl ch_trace03_66 0.451504n
CCH_trace03_66 ch_trace03_66 0 0.103795p
RCH_trace03_67 ch_trace03_66 ch_trace03_67_rl 0.00606066
LCH_trace03_67 ch_trace03_67_rl ch_trace03_67 0.451504n
CCH_trace03_67 ch_trace03_67 0 0.103795p
RCH_trace03_68 ch_trace03_67 ch_trace03_68_rl 0.00606066
LCH_trace03_68 ch_trace03_68_rl ch_trace03_68 0.451504n
CCH_trace03_68 ch_trace03_68 0 0.103795p
RCH_trace03_69 ch_trace03_68 ch_trace03_69_rl 0.00606066
LCH_trace03_69 ch_trace03_69_rl ch_trace03_69 0.451504n
CCH_trace03_69 ch_trace03_69 0 0.103795p
RCH_trace03_70 ch_trace03_69 ch_trace03_70_rl 0.00606066
LCH_trace03_70 ch_trace03_70_rl ch_trace03_70 0.451504n
CCH_trace03_70 ch_trace03_70 0 0.103795p
RCH_trace03_71 ch_trace03_70 ch_trace03_71_rl 0.00606066
LCH_trace03_71 ch_trace03_71_rl ch_trace03_71 0.451504n
CCH_trace03_71 ch_trace03_71 0 0.103795p
RCH_trace03_72 ch_trace03_71 ch_trace03_72_rl 0.00606066
LCH_trace03_72 ch_trace03_72_rl ch_trace03_72 0.451504n
CCH_trace03_72 ch_trace03_72 0 0.103795p
RCH_trace03_73 ch_trace03_72 ch_trace03_73_rl 0.00606066
LCH_trace03_73 ch_trace03_73_rl ch_trace03_73 0.451504n
CCH_trace03_73 ch_trace03_73 0 0.103795p
RCH_trace03_74 ch_trace03_73 ch_trace03_74_rl 0.00606066
LCH_trace03_74 ch_trace03_74_rl ch_trace03_74 0.451504n
CCH_trace03_74 ch_trace03_74 0 0.103795p
RCH_trace03_75 ch_trace03_74 ch_trace03_75_rl 0.00606066
LCH_trace03_75 ch_trace03_75_rl ch_trace03_75 0.451504n
CCH_trace03_75 ch_trace03_75 0 0.103795p
RCH_trace03_76 ch_trace03_75 ch_trace03_76_rl 0.00606066
LCH_trace03_76 ch_trace03_76_rl ch_trace03_76 0.451504n
CCH_trace03_76 ch_trace03_76 0 0.103795p
RCH_trace03_77 ch_trace03_76 ch_trace03_77_rl 0.00606066
LCH_trace03_77 ch_trace03_77_rl ch_trace03_77 0.451504n
CCH_trace03_77 ch_trace03_77 0 0.103795p
RCH_trace03_78 ch_trace03_77 ch_trace03_78_rl 0.00606066
LCH_trace03_78 ch_trace03_78_rl ch_trace03_78 0.451504n
CCH_trace03_78 ch_trace03_78 0 0.103795p
RCH_trace03_79 ch_trace03_78 ch_trace03_79_rl 0.00606066
LCH_trace03_79 ch_trace03_79_rl ch_trace03_79 0.451504n
CCH_trace03_79 ch_trace03_79 0 0.103795p
RCH_trace03_80 ch_trace03_79 ch_trace03_80_rl 0.00606066
LCH_trace03_80 ch_trace03_80_rl pad_trace03 0.451504n
CCH_trace03_80 pad_trace03 0 0.103795p
RLOAD_trace03 pad_trace03 0 1160

.save V(in_dig) V(src_trace01) V(pad_trace01) V(xtrace01.ku) V(xtrace01.kd) V(src_trace02) V(pad_trace02) V(xtrace02.ku) V(xtrace02.kd) V(src_trace03) V(pad_trace03) V(xtrace03.ku) V(xtrace03.kd)
.tran 10p 230n
.end
