* Generated by scripts/ngspice_lab.py
.temp 25
.options method=gear maxord=2 reltol=0.0001 abstol=1e-12 vntol=1e-07 gmin=1e-12
Vin in_dig 0 PWL(0n 0 10n 0 10.005n 1.2 30n 1.2 30.005n 0 50n 0 50.005n 1.2 70n 1.2 70.005n 0 90n 0 90.005n 1.2 110n 1.2 110.005n 0 130n 0 130.005n 1.2 150n 1.2 150.005n 0 170n 0 170.005n 1.2 190n 1.2 190.005n 0 230n 0)
Ven en_sig 0 DC 1.2
Vdd vdd 0 DC 1.2
.include 'C:/Users/simom/Desktop/Projects/IBIS_Comparison/results/ngspice_lab_hibiki_1160_5pulse/converted/hibiki_i3c_0p125ma_I3C_TX_0p125mA_tx_Typical.sub'
Xhibiki_i3c_0p125ma src_hibiki_i3c_0p125ma in_dig en_sig vdd 0 I3C_TX_0p125mA_tx_OutputInput_Typical
RLOAD_hibiki_i3c_0p125ma src_hibiki_i3c_0p125ma 0 1160
.save V(in_dig) V(src_hibiki_i3c_0p125ma) V(xhibiki_i3c_0p125ma.ku) V(xhibiki_i3c_0p125ma.kd)
.tran 10p 230n
.end
