* EQUIVALENT CIRCUIT FOR VECTOR FITTED S-MATRIX
* Created using scikit-rf vectorFitting.py
*
.SUBCKT s_equivalent p1 p2
*
* Port network for port 1
V1 p1 s1 0
R1 s1 0 50.0
Gd1_1 0 s1 p1 0 0.005350276845456796
Fd1_1 0 s1 V1 0.2675138422728398
Gr1_1_1 0 s1 x1_a1 0 -25423409461.033474
Gr2_re_1_1 0 s1 x2_re_a1 0 4514971872.913804
Gr2_im_1_1 0 s1 x2_im_a1 0 1684712775.333124
Gr3_re_1_1 0 s1 x3_re_a1 0 2087321391.0098326
Gr3_im_1_1 0 s1 x3_im_a1 0 1360674511.9119382
Gr4_re_1_1 0 s1 x4_re_a1 0 -38964318.532601915
Gr4_im_1_1 0 s1 x4_im_a1 0 -356739176.52499884
Gr5_re_1_1 0 s1 x5_re_a1 0 6789372.941575928
Gr5_im_1_1 0 s1 x5_im_a1 0 6466958.924565581
Gr6_re_1_1 0 s1 x6_re_a1 0 4404186573.827263
Gr6_im_1_1 0 s1 x6_im_a1 0 9387486602.904158
Gr7_re_1_1 0 s1 x7_re_a1 0 -23488211788.880264
Gr7_im_1_1 0 s1 x7_im_a1 0 3054891756.4088106
Gr8_re_1_1 0 s1 x8_re_a1 0 165189382.86530215
Gr8_im_1_1 0 s1 x8_im_a1 0 -12925316650.247276
Gr9_re_1_1 0 s1 x9_re_a1 0 3898914524.7831864
Gr9_im_1_1 0 s1 x9_im_a1 0 -3167578156.167606
Gr10_re_1_1 0 s1 x10_re_a1 0 -918079968.3541367
Gr10_im_1_1 0 s1 x10_im_a1 0 -730859685.0754488
Gr11_re_1_1 0 s1 x11_re_a1 0 2481748377.071528
Gr11_im_1_1 0 s1 x11_im_a1 0 -1952621771.950767
Gr12_re_1_1 0 s1 x12_re_a1 0 1628312035.654511
Gr12_im_1_1 0 s1 x12_im_a1 0 -2494277304.798336
Gr13_re_1_1 0 s1 x13_re_a1 0 -10578432.016401885
Gr13_im_1_1 0 s1 x13_im_a1 0 12385482.751739495
Gr14_re_1_1 0 s1 x14_re_a1 0 -1828224029.3213463
Gr14_im_1_1 0 s1 x14_im_a1 0 -4081770736.3712277
Gr15_re_1_1 0 s1 x15_re_a1 0 -151482920.49088678
Gr15_im_1_1 0 s1 x15_im_a1 0 -3389252.502443847
Gr16_re_1_1 0 s1 x16_re_a1 0 -2540975.474108691
Gr16_im_1_1 0 s1 x16_im_a1 0 -3959251.210845949
Gr17_re_1_1 0 s1 x17_re_a1 0 -1584129461.148481
Gr17_im_1_1 0 s1 x17_im_a1 0 1134015175.3649123
Gr18_re_1_1 0 s1 x18_re_a1 0 1648410315.0520492
Gr18_im_1_1 0 s1 x18_im_a1 0 34748104.084998354
Gr19_re_1_1 0 s1 x19_re_a1 0 -61944111.4904879
Gr19_im_1_1 0 s1 x19_im_a1 0 -65009782.55726403
Gr20_re_1_1 0 s1 x20_re_a1 0 -515833236.13134664
Gr20_im_1_1 0 s1 x20_im_a1 0 -1929642.1960006654
Gr21_re_1_1 0 s1 x21_re_a1 0 826217.3175389229
Gr21_im_1_1 0 s1 x21_im_a1 0 651270.3304057713
Gr22_re_1_1 0 s1 x22_re_a1 0 -995211.1123513742
Gr22_im_1_1 0 s1 x22_im_a1 0 -7399885.283124078
Gd1_2 0 s1 p2 0 0.0016534908762680393
Fd1_2 0 s1 V2 0.08267454381340197
Gr1_1_2 0 s1 x1_a2 0 -3493627424.929018
Gr2_re_1_2 0 s1 x2_re_a2 0 724824230.5863001
Gr2_im_1_2 0 s1 x2_im_a2 0 -1458218169.6163926
Gr3_re_1_2 0 s1 x3_re_a2 0 -666081847.3043721
Gr3_im_1_2 0 s1 x3_im_a2 0 482556869.0982685
Gr4_re_1_2 0 s1 x4_re_a2 0 -154620487.62641385
Gr4_im_1_2 0 s1 x4_im_a2 0 54904067.15706998
Gr5_re_1_2 0 s1 x5_re_a2 0 -4407716.164142894
Gr5_im_1_2 0 s1 x5_im_a2 0 2558973.0662378366
Gr6_re_1_2 0 s1 x6_re_a2 0 1443346033.1760771
Gr6_im_1_2 0 s1 x6_im_a2 0 -1707601758.393463
Gr7_re_1_2 0 s1 x7_re_a2 0 -3511665936.471899
Gr7_im_1_2 0 s1 x7_im_a2 0 749281296.3807815
Gr8_re_1_2 0 s1 x8_re_a2 0 5603792568.586945
Gr8_im_1_2 0 s1 x8_im_a2 0 -655204068.7697004
Gr9_re_1_2 0 s1 x9_re_a2 0 -4269943329.2568483
Gr9_im_1_2 0 s1 x9_im_a2 0 3362290297.953476
Gr10_re_1_2 0 s1 x10_re_a2 0 2648078602.6184273
Gr10_im_1_2 0 s1 x10_im_a2 0 -1007077909.0145533
Gr11_re_1_2 0 s1 x11_re_a2 0 422331627.5486279
Gr11_im_1_2 0 s1 x11_im_a2 0 887769493.4235085
Gr12_re_1_2 0 s1 x12_re_a2 0 -3778277882.4833817
Gr12_im_1_2 0 s1 x12_im_a2 0 60211809.00273525
Gr13_re_1_2 0 s1 x13_re_a2 0 -13137227.154957432
Gr13_im_1_2 0 s1 x13_im_a2 0 12694334.975844136
Gr14_re_1_2 0 s1 x14_re_a2 0 -293993360.9289261
Gr14_im_1_2 0 s1 x14_im_a2 0 -2556147091.935854
Gr15_re_1_2 0 s1 x15_re_a2 0 -154906368.39183125
Gr15_im_1_2 0 s1 x15_im_a2 0 -23888760.84748201
Gr16_re_1_2 0 s1 x16_re_a2 0 -3749327.6245755814
Gr16_im_1_2 0 s1 x16_im_a2 0 -1207355.3959370744
Gr17_re_1_2 0 s1 x17_re_a2 0 -504066259.4524695
Gr17_im_1_2 0 s1 x17_im_a2 0 -43862016.908477604
Gr18_re_1_2 0 s1 x18_re_a2 0 2297014573.3742185
Gr18_im_1_2 0 s1 x18_im_a2 0 -490562474.2084917
Gr19_re_1_2 0 s1 x19_re_a2 0 -1398738082.9657154
Gr19_im_1_2 0 s1 x19_im_a2 0 1637594464.484406
Gr20_re_1_2 0 s1 x20_re_a2 0 -545447596.9444277
Gr20_im_1_2 0 s1 x20_im_a2 0 -266988057.35605574
Gr21_re_1_2 0 s1 x21_re_a2 0 1473907.7114163197
Gr21_im_1_2 0 s1 x21_im_a2 0 -2613995.388803736
Gr22_re_1_2 0 s1 x22_re_a2 0 -9003352.81089494
Gr22_im_1_2 0 s1 x22_im_a2 0 2094846.4125282366
*
* State networks driven by port 1
Cx1_a1 x1_a1 0 1.0
Gx1_a1 0 x1_a1 p1 0 0.07071067811865475
Fx1_a1 0 x1_a1 V1 3.5355339059327378
Rp1_a1 0 x1_a1 1.5367610098607795e-11
Cx2_re_a1 x2_re_a1 0 1.0
Gx2_re_a1 0 x2_re_a1 p1 0 0.1414213562373095
Fx2_re_a1 0 x2_re_a1 V1 7.0710678118654755
Rp2_re_re_a1 0 x2_re_a1 5.578047363074271e-11
Gp2_re_im_a1 0 x2_re_a1 x2_im_a1 0 536925037876.58386
Cx2_im_a1 x2_im_a1 0 1.0
Gp2_im_re_a1 0 x2_im_a1 x2_re_a1 0 -536925037876.58386
Rp2_im_im_a1 0 x2_im_a1 5.578047363074271e-11
Cx3_re_a1 x3_re_a1 0 1.0
Gx3_re_a1 0 x3_re_a1 p1 0 0.1414213562373095
Fx3_re_a1 0 x3_re_a1 V1 7.0710678118654755
Rp3_re_re_a1 0 x3_re_a1 2.529328798808015e-10
Gp3_re_im_a1 0 x3_re_a1 x3_im_a1 0 441051708980.2641
Cx3_im_a1 x3_im_a1 0 1.0
Gp3_im_re_a1 0 x3_im_a1 x3_re_a1 0 -441051708980.2641
Rp3_im_im_a1 0 x3_im_a1 2.529328798808015e-10
Cx4_re_a1 x4_re_a1 0 1.0
Gx4_re_a1 0 x4_re_a1 p1 0 0.1414213562373095
Fx4_re_a1 0 x4_re_a1 V1 7.0710678118654755
Rp4_re_re_a1 0 x4_re_a1 3.5200852114856275e-10
Gp4_re_im_a1 0 x4_re_a1 x4_im_a1 0 444907273708.5452
Cx4_im_a1 x4_im_a1 0 1.0
Gp4_im_re_a1 0 x4_im_a1 x4_re_a1 0 -444907273708.5452
Rp4_im_im_a1 0 x4_im_a1 3.5200852114856275e-10
Cx5_re_a1 x5_re_a1 0 1.0
Gx5_re_a1 0 x5_re_a1 p1 0 0.1414213562373095
Fx5_re_a1 0 x5_re_a1 V1 7.0710678118654755
Rp5_re_re_a1 0 x5_re_a1 2.4261047418450236e-09
Gp5_re_im_a1 0 x5_re_a1 x5_im_a1 0 451181443516.2154
Cx5_im_a1 x5_im_a1 0 1.0
Gp5_im_re_a1 0 x5_im_a1 x5_re_a1 0 -451181443516.2154
Rp5_im_im_a1 0 x5_im_a1 2.4261047418450236e-09
Cx6_re_a1 x6_re_a1 0 1.0
Gx6_re_a1 0 x6_re_a1 p1 0 0.1414213562373095
Fx6_re_a1 0 x6_re_a1 V1 7.0710678118654755
Rp6_re_re_a1 0 x6_re_a1 1.5315247325514604e-10
Gp6_re_im_a1 0 x6_re_a1 x6_im_a1 0 451366147435.30884
Cx6_im_a1 x6_im_a1 0 1.0
Gp6_im_re_a1 0 x6_im_a1 x6_re_a1 0 -451366147435.30884
Rp6_im_im_a1 0 x6_im_a1 1.5315247325514604e-10
Cx7_re_a1 x7_re_a1 0 1.0
Gx7_re_a1 0 x7_re_a1 p1 0 0.1414213562373095
Fx7_re_a1 0 x7_re_a1 V1 7.0710678118654755
Rp7_re_re_a1 0 x7_re_a1 1.089114739509385e-10
Gp7_re_im_a1 0 x7_re_a1 x7_im_a1 0 458456458295.1029
Cx7_im_a1 x7_im_a1 0 1.0
Gp7_im_re_a1 0 x7_im_a1 x7_re_a1 0 -458456458295.1029
Rp7_im_im_a1 0 x7_im_a1 1.089114739509385e-10
Cx8_re_a1 x8_re_a1 0 1.0
Gx8_re_a1 0 x8_re_a1 p1 0 0.1414213562373095
Fx8_re_a1 0 x8_re_a1 V1 7.0710678118654755
Rp8_re_re_a1 0 x8_re_a1 1.282811646453746e-10
Gp8_re_im_a1 0 x8_re_a1 x8_im_a1 0 466339285368.87286
Cx8_im_a1 x8_im_a1 0 1.0
Gp8_im_re_a1 0 x8_im_a1 x8_re_a1 0 -466339285368.87286
Rp8_im_im_a1 0 x8_im_a1 1.282811646453746e-10
Cx9_re_a1 x9_re_a1 0 1.0
Gx9_re_a1 0 x9_re_a1 p1 0 0.1414213562373095
Fx9_re_a1 0 x9_re_a1 V1 7.0710678118654755
Rp9_re_re_a1 0 x9_re_a1 1.2540133541285125e-10
Gp9_re_im_a1 0 x9_re_a1 x9_im_a1 0 476358620443.5034
Cx9_im_a1 x9_im_a1 0 1.0
Gp9_im_re_a1 0 x9_im_a1 x9_re_a1 0 -476358620443.5034
Rp9_im_im_a1 0 x9_im_a1 1.2540133541285125e-10
Cx10_re_a1 x10_re_a1 0 1.0
Gx10_re_a1 0 x10_re_a1 p1 0 0.1414213562373095
Fx10_re_a1 0 x10_re_a1 V1 7.0710678118654755
Rp10_re_re_a1 0 x10_re_a1 1.367219050492465e-10
Gp10_re_im_a1 0 x10_re_a1 x10_im_a1 0 484978980425.3123
Cx10_im_a1 x10_im_a1 0 1.0
Gp10_im_re_a1 0 x10_im_a1 x10_re_a1 0 -484978980425.3123
Rp10_im_im_a1 0 x10_im_a1 1.367219050492465e-10
Cx11_re_a1 x11_re_a1 0 1.0
Gx11_re_a1 0 x11_re_a1 p1 0 0.1414213562373095
Fx11_re_a1 0 x11_re_a1 V1 7.0710678118654755
Rp11_re_re_a1 0 x11_re_a1 1.995273754417683e-10
Gp11_re_im_a1 0 x11_re_a1 x11_im_a1 0 533025553596.8224
Cx11_im_a1 x11_im_a1 0 1.0
Gp11_im_re_a1 0 x11_im_a1 x11_re_a1 0 -533025553596.8224
Rp11_im_im_a1 0 x11_im_a1 1.995273754417683e-10
Cx12_re_a1 x12_re_a1 0 1.0
Gx12_re_a1 0 x12_re_a1 p1 0 0.1414213562373095
Fx12_re_a1 0 x12_re_a1 V1 7.0710678118654755
Rp12_re_re_a1 0 x12_re_a1 1.4460061063581543e-10
Gp12_re_im_a1 0 x12_re_a1 x12_im_a1 0 492223398138.6739
Cx12_im_a1 x12_im_a1 0 1.0
Gp12_im_re_a1 0 x12_im_a1 x12_re_a1 0 -492223398138.6739
Rp12_im_im_a1 0 x12_im_a1 1.4460061063581543e-10
Cx13_re_a1 x13_re_a1 0 1.0
Gx13_re_a1 0 x13_re_a1 p1 0 0.1414213562373095
Fx13_re_a1 0 x13_re_a1 V1 7.0710678118654755
Rp13_re_re_a1 0 x13_re_a1 1.1163485816893758e-09
Gp13_re_im_a1 0 x13_re_a1 x13_im_a1 0 496671536534.38184
Cx13_im_a1 x13_im_a1 0 1.0
Gp13_im_re_a1 0 x13_im_a1 x13_re_a1 0 -496671536534.38184
Rp13_im_im_a1 0 x13_im_a1 1.1163485816893758e-09
Cx14_re_a1 x14_re_a1 0 1.0
Gx14_re_a1 0 x14_re_a1 p1 0 0.1414213562373095
Fx14_re_a1 0 x14_re_a1 V1 7.0710678118654755
Rp14_re_re_a1 0 x14_re_a1 1.8106825350308217e-10
Gp14_re_im_a1 0 x14_re_a1 x14_im_a1 0 526167894189.9872
Cx14_im_a1 x14_im_a1 0 1.0
Gp14_im_re_a1 0 x14_im_a1 x14_re_a1 0 -526167894189.9872
Rp14_im_im_a1 0 x14_im_a1 1.8106825350308217e-10
Cx15_re_a1 x15_re_a1 0 1.0
Gx15_re_a1 0 x15_re_a1 p1 0 0.1414213562373095
Fx15_re_a1 0 x15_re_a1 V1 7.0710678118654755
Rp15_re_re_a1 0 x15_re_a1 5.31491953963698e-10
Gp15_re_im_a1 0 x15_re_a1 x15_im_a1 0 524153341488.06934
Cx15_im_a1 x15_im_a1 0 1.0
Gp15_im_re_a1 0 x15_im_a1 x15_re_a1 0 -524153341488.06934
Rp15_im_im_a1 0 x15_im_a1 5.31491953963698e-10
Cx16_re_a1 x16_re_a1 0 1.0
Gx16_re_a1 0 x16_re_a1 p1 0 0.1414213562373095
Fx16_re_a1 0 x16_re_a1 V1 7.0710678118654755
Rp16_re_re_a1 0 x16_re_a1 1.3515413599330728e-08
Gp16_re_im_a1 0 x16_re_a1 x16_im_a1 0 525702319579.23456
Cx16_im_a1 x16_im_a1 0 1.0
Gp16_im_re_a1 0 x16_im_a1 x16_re_a1 0 -525702319579.23456
Rp16_im_im_a1 0 x16_im_a1 1.3515413599330728e-08
Cx17_re_a1 x17_re_a1 0 1.0
Gx17_re_a1 0 x17_re_a1 p1 0 0.1414213562373095
Fx17_re_a1 0 x17_re_a1 V1 7.0710678118654755
Rp17_re_re_a1 0 x17_re_a1 1.7275207575091853e-10
Gp17_re_im_a1 0 x17_re_a1 x17_im_a1 0 521353584056.0092
Cx17_im_a1 x17_im_a1 0 1.0
Gp17_im_re_a1 0 x17_im_a1 x17_re_a1 0 -521353584056.0092
Rp17_im_im_a1 0 x17_im_a1 1.7275207575091853e-10
Cx18_re_a1 x18_re_a1 0 1.0
Gx18_re_a1 0 x18_re_a1 p1 0 0.1414213562373095
Fx18_re_a1 0 x18_re_a1 V1 7.0710678118654755
Rp18_re_re_a1 0 x18_re_a1 1.5115731395815119e-10
Gp18_re_im_a1 0 x18_re_a1 x18_im_a1 0 502816776247.36053
Cx18_im_a1 x18_im_a1 0 1.0
Gp18_im_re_a1 0 x18_im_a1 x18_re_a1 0 -502816776247.36053
Rp18_im_im_a1 0 x18_im_a1 1.5115731395815119e-10
Cx19_re_a1 x19_re_a1 0 1.0
Gx19_re_a1 0 x19_re_a1 p1 0 0.1414213562373095
Fx19_re_a1 0 x19_re_a1 V1 7.0710678118654755
Rp19_re_re_a1 0 x19_re_a1 1.9185802266543982e-10
Gp19_re_im_a1 0 x19_re_a1 x19_im_a1 0 514229488164.91797
Cx19_im_a1 x19_im_a1 0 1.0
Gp19_im_re_a1 0 x19_im_a1 x19_re_a1 0 -514229488164.91797
Rp19_im_im_a1 0 x19_im_a1 1.9185802266543982e-10
Cx20_re_a1 x20_re_a1 0 1.0
Gx20_re_a1 0 x20_re_a1 p1 0 0.1414213562373095
Fx20_re_a1 0 x20_re_a1 V1 7.0710678118654755
Rp20_re_re_a1 0 x20_re_a1 2.36531619046301e-10
Gp20_re_im_a1 0 x20_re_a1 x20_im_a1 0 507614835498.9133
Cx20_im_a1 x20_im_a1 0 1.0
Gp20_im_re_a1 0 x20_im_a1 x20_re_a1 0 -507614835498.9133
Rp20_im_im_a1 0 x20_im_a1 2.36531619046301e-10
Cx21_re_a1 x21_re_a1 0 1.0
Gx21_re_a1 0 x21_re_a1 p1 0 0.1414213562373095
Fx21_re_a1 0 x21_re_a1 V1 7.0710678118654755
Rp21_re_re_a1 0 x21_re_a1 2.3580923239344224e-08
Gp21_re_im_a1 0 x21_re_a1 x21_im_a1 0 509829715378.3856
Cx21_im_a1 x21_im_a1 0 1.0
Gp21_im_re_a1 0 x21_im_a1 x21_re_a1 0 -509829715378.3856
Rp21_im_im_a1 0 x21_im_a1 2.3580923239344224e-08
Cx22_re_a1 x22_re_a1 0 1.0
Gx22_re_a1 0 x22_re_a1 p1 0 0.1414213562373095
Fx22_re_a1 0 x22_re_a1 V1 7.0710678118654755
Rp22_re_re_a1 0 x22_re_a1 1.7126128646692673e-08
Gp22_re_im_a1 0 x22_re_a1 x22_im_a1 0 509168228853.63367
Cx22_im_a1 x22_im_a1 0 1.0
Gp22_im_re_a1 0 x22_im_a1 x22_re_a1 0 -509168228853.63367
Rp22_im_im_a1 0 x22_im_a1 1.7126128646692673e-08
*
* Port network for port 2
V2 p2 s2 0
R2 s2 0 50.0
Gd2_1 0 s2 p1 0 0.0016534908762680393
Fd2_1 0 s2 V1 0.08267454381340197
Gr1_2_1 0 s2 x1_a1 0 -3493627424.9290185
Gr2_re_2_1 0 s2 x2_re_a1 0 724824230.5863003
Gr2_im_2_1 0 s2 x2_im_a1 0 -1458218169.6163933
Gr3_re_2_1 0 s2 x3_re_a1 0 -666081847.3043724
Gr3_im_2_1 0 s2 x3_im_a1 0 482556869.0982687
Gr4_re_2_1 0 s2 x4_re_a1 0 -154620487.62641382
Gr4_im_2_1 0 s2 x4_im_a1 0 54904067.15706958
Gr5_re_2_1 0 s2 x5_re_a1 0 -4407716.164142887
Gr5_im_2_1 0 s2 x5_im_a1 0 2558973.0662377756
Gr6_re_2_1 0 s2 x6_re_a1 0 1443346033.1760774
Gr6_im_2_1 0 s2 x6_im_a1 0 -1707601758.3934643
Gr7_re_2_1 0 s2 x7_re_a1 0 -3511665936.4718976
Gr7_im_2_1 0 s2 x7_im_a1 0 749281296.3807814
Gr8_re_2_1 0 s2 x8_re_a1 0 5603792568.586946
Gr8_im_2_1 0 s2 x8_im_a1 0 -655204068.769699
Gr9_re_2_1 0 s2 x9_re_a1 0 -4269943329.25685
Gr9_im_2_1 0 s2 x9_im_a1 0 3362290297.953477
Gr10_re_2_1 0 s2 x10_re_a1 0 2648078602.618427
Gr10_im_2_1 0 s2 x10_im_a1 0 -1007077909.0145531
Gr11_re_2_1 0 s2 x11_re_a1 0 422331627.5486276
Gr11_im_2_1 0 s2 x11_im_a1 0 887769493.4235084
Gr12_re_2_1 0 s2 x12_re_a1 0 -3778277882.483382
Gr12_im_2_1 0 s2 x12_im_a1 0 60211809.00273461
Gr13_re_2_1 0 s2 x13_re_a1 0 -13137227.154957337
Gr13_im_2_1 0 s2 x13_im_a1 0 12694334.975844152
Gr14_re_2_1 0 s2 x14_re_a1 0 -293993360.9289264
Gr14_im_2_1 0 s2 x14_im_a1 0 -2556147091.9358535
Gr15_re_2_1 0 s2 x15_re_a1 0 -154906368.39183125
Gr15_im_2_1 0 s2 x15_im_a1 0 -23888760.84748201
Gr16_re_2_1 0 s2 x16_re_a1 0 -3749327.6245755735
Gr16_im_2_1 0 s2 x16_im_a1 0 -1207355.3959370914
Gr17_re_2_1 0 s2 x17_re_a1 0 -504066259.45246977
Gr17_im_2_1 0 s2 x17_im_a1 0 -43862016.90847748
Gr18_re_2_1 0 s2 x18_re_a1 0 2297014573.374219
Gr18_im_2_1 0 s2 x18_im_a1 0 -490562474.20849156
Gr19_re_2_1 0 s2 x19_re_a1 0 -1398738082.9657156
Gr19_im_2_1 0 s2 x19_im_a1 0 1637594464.4844058
Gr20_re_2_1 0 s2 x20_re_a1 0 -545447596.9444276
Gr20_im_2_1 0 s2 x20_im_a1 0 -266988057.35605595
Gr21_re_2_1 0 s2 x21_re_a1 0 1473907.7114163316
Gr21_im_2_1 0 s2 x21_im_a1 0 -2613995.3888037335
Gr22_re_2_1 0 s2 x22_re_a1 0 -9003352.81089494
Gr22_im_2_1 0 s2 x22_im_a1 0 2094846.4125282124
Gd2_2 0 s2 p2 0 -0.009843074060883002
Fd2_2 0 s2 V2 -0.4921537030441502
Gr1_2_2 0 s2 x1_a2 0 27429509887.95941
Gr2_re_2_2 0 s2 x2_re_a2 0 -26287668872.464058
Gr2_im_2_2 0 s2 x2_im_a2 0 26269865538.378235
Gr3_re_2_2 0 s2 x3_re_a2 0 2250984345.7301607
Gr3_im_2_2 0 s2 x3_im_a2 0 -1019843170.1358132
Gr4_re_2_2 0 s2 x4_re_a2 0 1610130760.840421
Gr4_im_2_2 0 s2 x4_im_a2 0 1190605376.9033074
Gr5_re_2_2 0 s2 x5_re_a2 0 -18985068.833836414
Gr5_im_2_2 0 s2 x5_im_a2 0 -84463400.91366483
Gr6_re_2_2 0 s2 x6_re_a2 0 4770388009.973483
Gr6_im_2_2 0 s2 x6_im_a2 0 9494310234.460508
Gr7_re_2_2 0 s2 x7_re_a2 0 -20852234569.053547
Gr7_im_2_2 0 s2 x7_im_a2 0 8883816870.211355
Gr8_re_2_2 0 s2 x8_re_a2 0 -10675912205.471033
Gr8_im_2_2 0 s2 x8_im_a2 0 -11677611667.075506
Gr9_re_2_2 0 s2 x9_re_a2 0 -7237712710.184508
Gr9_im_2_2 0 s2 x9_im_a2 0 -14471174018.66913
Gr10_re_2_2 0 s2 x10_re_a2 0 1416068231.0734031
Gr10_im_2_2 0 s2 x10_im_a2 0 -17303396581.61913
Gr11_re_2_2 0 s2 x11_re_a2 0 -2281030292.2526245
Gr11_im_2_2 0 s2 x11_im_a2 0 4559853161.317067
Gr12_re_2_2 0 s2 x12_re_a2 0 11946449486.3789
Gr12_im_2_2 0 s2 x12_im_a2 0 -11003281251.376503
Gr13_re_2_2 0 s2 x13_re_a2 0 220379872.2417316
Gr13_im_2_2 0 s2 x13_im_a2 0 -118740794.93761384
Gr14_re_2_2 0 s2 x14_re_a2 0 -1803366056.5339437
Gr14_im_2_2 0 s2 x14_im_a2 0 27322808857.36113
Gr15_re_2_2 0 s2 x15_re_a2 0 1944648794.8111942
Gr15_im_2_2 0 s2 x15_im_a2 0 816586301.9100095
Gr16_re_2_2 0 s2 x16_re_a2 0 55693350.1530682
Gr16_im_2_2 0 s2 x16_im_a2 0 49243713.37565588
Gr17_re_2_2 0 s2 x17_re_a2 0 30949142911.069332
Gr17_im_2_2 0 s2 x17_im_a2 0 -1649351155.6765256
Gr18_re_2_2 0 s2 x18_re_a2 0 12544432871.783005
Gr18_im_2_2 0 s2 x18_im_a2 0 -15444188194.53554
Gr19_re_2_2 0 s2 x19_re_a2 0 13808930573.375566
Gr19_im_2_2 0 s2 x19_im_a2 0 -2446490953.3152523
Gr20_re_2_2 0 s2 x20_re_a2 0 9062024397.969698
Gr20_im_2_2 0 s2 x20_im_a2 0 -81206920.87226659
Gr21_re_2_2 0 s2 x21_re_a2 0 -27506627.572142906
Gr21_im_2_2 0 s2 x21_im_a2 0 4909707.97410133
Gr22_re_2_2 0 s2 x22_re_a2 0 82466576.18658744
Gr22_im_2_2 0 s2 x22_im_a2 0 112526903.15200596
*
* State networks driven by port 2
Cx1_a2 x1_a2 0 1.0
Gx1_a2 0 x1_a2 p2 0 0.07071067811865475
Fx1_a2 0 x1_a2 V2 3.5355339059327378
Rp1_a2 0 x1_a2 1.5367610098607795e-11
Cx2_re_a2 x2_re_a2 0 1.0
Gx2_re_a2 0 x2_re_a2 p2 0 0.1414213562373095
Fx2_re_a2 0 x2_re_a2 V2 7.0710678118654755
Rp2_re_re_a2 0 x2_re_a2 5.578047363074271e-11
Gp2_re_im_a2 0 x2_re_a2 x2_im_a2 0 536925037876.58386
Cx2_im_a2 x2_im_a2 0 1.0
Gp2_im_re_a2 0 x2_im_a2 x2_re_a2 0 -536925037876.58386
Rp2_im_im_a2 0 x2_im_a2 5.578047363074271e-11
Cx3_re_a2 x3_re_a2 0 1.0
Gx3_re_a2 0 x3_re_a2 p2 0 0.1414213562373095
Fx3_re_a2 0 x3_re_a2 V2 7.0710678118654755
Rp3_re_re_a2 0 x3_re_a2 2.529328798808015e-10
Gp3_re_im_a2 0 x3_re_a2 x3_im_a2 0 441051708980.2641
Cx3_im_a2 x3_im_a2 0 1.0
Gp3_im_re_a2 0 x3_im_a2 x3_re_a2 0 -441051708980.2641
Rp3_im_im_a2 0 x3_im_a2 2.529328798808015e-10
Cx4_re_a2 x4_re_a2 0 1.0
Gx4_re_a2 0 x4_re_a2 p2 0 0.1414213562373095
Fx4_re_a2 0 x4_re_a2 V2 7.0710678118654755
Rp4_re_re_a2 0 x4_re_a2 3.5200852114856275e-10
Gp4_re_im_a2 0 x4_re_a2 x4_im_a2 0 444907273708.5452
Cx4_im_a2 x4_im_a2 0 1.0
Gp4_im_re_a2 0 x4_im_a2 x4_re_a2 0 -444907273708.5452
Rp4_im_im_a2 0 x4_im_a2 3.5200852114856275e-10
Cx5_re_a2 x5_re_a2 0 1.0
Gx5_re_a2 0 x5_re_a2 p2 0 0.1414213562373095
Fx5_re_a2 0 x5_re_a2 V2 7.0710678118654755
Rp5_re_re_a2 0 x5_re_a2 2.4261047418450236e-09
Gp5_re_im_a2 0 x5_re_a2 x5_im_a2 0 451181443516.2154
Cx5_im_a2 x5_im_a2 0 1.0
Gp5_im_re_a2 0 x5_im_a2 x5_re_a2 0 -451181443516.2154
Rp5_im_im_a2 0 x5_im_a2 2.4261047418450236e-09
Cx6_re_a2 x6_re_a2 0 1.0
Gx6_re_a2 0 x6_re_a2 p2 0 0.1414213562373095
Fx6_re_a2 0 x6_re_a2 V2 7.0710678118654755
Rp6_re_re_a2 0 x6_re_a2 1.5315247325514604e-10
Gp6_re_im_a2 0 x6_re_a2 x6_im_a2 0 451366147435.30884
Cx6_im_a2 x6_im_a2 0 1.0
Gp6_im_re_a2 0 x6_im_a2 x6_re_a2 0 -451366147435.30884
Rp6_im_im_a2 0 x6_im_a2 1.5315247325514604e-10
Cx7_re_a2 x7_re_a2 0 1.0
Gx7_re_a2 0 x7_re_a2 p2 0 0.1414213562373095
Fx7_re_a2 0 x7_re_a2 V2 7.0710678118654755
Rp7_re_re_a2 0 x7_re_a2 1.089114739509385e-10
Gp7_re_im_a2 0 x7_re_a2 x7_im_a2 0 458456458295.1029
Cx7_im_a2 x7_im_a2 0 1.0
Gp7_im_re_a2 0 x7_im_a2 x7_re_a2 0 -458456458295.1029
Rp7_im_im_a2 0 x7_im_a2 1.089114739509385e-10
Cx8_re_a2 x8_re_a2 0 1.0
Gx8_re_a2 0 x8_re_a2 p2 0 0.1414213562373095
Fx8_re_a2 0 x8_re_a2 V2 7.0710678118654755
Rp8_re_re_a2 0 x8_re_a2 1.282811646453746e-10
Gp8_re_im_a2 0 x8_re_a2 x8_im_a2 0 466339285368.87286
Cx8_im_a2 x8_im_a2 0 1.0
Gp8_im_re_a2 0 x8_im_a2 x8_re_a2 0 -466339285368.87286
Rp8_im_im_a2 0 x8_im_a2 1.282811646453746e-10
Cx9_re_a2 x9_re_a2 0 1.0
Gx9_re_a2 0 x9_re_a2 p2 0 0.1414213562373095
Fx9_re_a2 0 x9_re_a2 V2 7.0710678118654755
Rp9_re_re_a2 0 x9_re_a2 1.2540133541285125e-10
Gp9_re_im_a2 0 x9_re_a2 x9_im_a2 0 476358620443.5034
Cx9_im_a2 x9_im_a2 0 1.0
Gp9_im_re_a2 0 x9_im_a2 x9_re_a2 0 -476358620443.5034
Rp9_im_im_a2 0 x9_im_a2 1.2540133541285125e-10
Cx10_re_a2 x10_re_a2 0 1.0
Gx10_re_a2 0 x10_re_a2 p2 0 0.1414213562373095
Fx10_re_a2 0 x10_re_a2 V2 7.0710678118654755
Rp10_re_re_a2 0 x10_re_a2 1.367219050492465e-10
Gp10_re_im_a2 0 x10_re_a2 x10_im_a2 0 484978980425.3123
Cx10_im_a2 x10_im_a2 0 1.0
Gp10_im_re_a2 0 x10_im_a2 x10_re_a2 0 -484978980425.3123
Rp10_im_im_a2 0 x10_im_a2 1.367219050492465e-10
Cx11_re_a2 x11_re_a2 0 1.0
Gx11_re_a2 0 x11_re_a2 p2 0 0.1414213562373095
Fx11_re_a2 0 x11_re_a2 V2 7.0710678118654755
Rp11_re_re_a2 0 x11_re_a2 1.995273754417683e-10
Gp11_re_im_a2 0 x11_re_a2 x11_im_a2 0 533025553596.8224
Cx11_im_a2 x11_im_a2 0 1.0
Gp11_im_re_a2 0 x11_im_a2 x11_re_a2 0 -533025553596.8224
Rp11_im_im_a2 0 x11_im_a2 1.995273754417683e-10
Cx12_re_a2 x12_re_a2 0 1.0
Gx12_re_a2 0 x12_re_a2 p2 0 0.1414213562373095
Fx12_re_a2 0 x12_re_a2 V2 7.0710678118654755
Rp12_re_re_a2 0 x12_re_a2 1.4460061063581543e-10
Gp12_re_im_a2 0 x12_re_a2 x12_im_a2 0 492223398138.6739
Cx12_im_a2 x12_im_a2 0 1.0
Gp12_im_re_a2 0 x12_im_a2 x12_re_a2 0 -492223398138.6739
Rp12_im_im_a2 0 x12_im_a2 1.4460061063581543e-10
Cx13_re_a2 x13_re_a2 0 1.0
Gx13_re_a2 0 x13_re_a2 p2 0 0.1414213562373095
Fx13_re_a2 0 x13_re_a2 V2 7.0710678118654755
Rp13_re_re_a2 0 x13_re_a2 1.1163485816893758e-09
Gp13_re_im_a2 0 x13_re_a2 x13_im_a2 0 496671536534.38184
Cx13_im_a2 x13_im_a2 0 1.0
Gp13_im_re_a2 0 x13_im_a2 x13_re_a2 0 -496671536534.38184
Rp13_im_im_a2 0 x13_im_a2 1.1163485816893758e-09
Cx14_re_a2 x14_re_a2 0 1.0
Gx14_re_a2 0 x14_re_a2 p2 0 0.1414213562373095
Fx14_re_a2 0 x14_re_a2 V2 7.0710678118654755
Rp14_re_re_a2 0 x14_re_a2 1.8106825350308217e-10
Gp14_re_im_a2 0 x14_re_a2 x14_im_a2 0 526167894189.9872
Cx14_im_a2 x14_im_a2 0 1.0
Gp14_im_re_a2 0 x14_im_a2 x14_re_a2 0 -526167894189.9872
Rp14_im_im_a2 0 x14_im_a2 1.8106825350308217e-10
Cx15_re_a2 x15_re_a2 0 1.0
Gx15_re_a2 0 x15_re_a2 p2 0 0.1414213562373095
Fx15_re_a2 0 x15_re_a2 V2 7.0710678118654755
Rp15_re_re_a2 0 x15_re_a2 5.31491953963698e-10
Gp15_re_im_a2 0 x15_re_a2 x15_im_a2 0 524153341488.06934
Cx15_im_a2 x15_im_a2 0 1.0
Gp15_im_re_a2 0 x15_im_a2 x15_re_a2 0 -524153341488.06934
Rp15_im_im_a2 0 x15_im_a2 5.31491953963698e-10
Cx16_re_a2 x16_re_a2 0 1.0
Gx16_re_a2 0 x16_re_a2 p2 0 0.1414213562373095
Fx16_re_a2 0 x16_re_a2 V2 7.0710678118654755
Rp16_re_re_a2 0 x16_re_a2 1.3515413599330728e-08
Gp16_re_im_a2 0 x16_re_a2 x16_im_a2 0 525702319579.23456
Cx16_im_a2 x16_im_a2 0 1.0
Gp16_im_re_a2 0 x16_im_a2 x16_re_a2 0 -525702319579.23456
Rp16_im_im_a2 0 x16_im_a2 1.3515413599330728e-08
Cx17_re_a2 x17_re_a2 0 1.0
Gx17_re_a2 0 x17_re_a2 p2 0 0.1414213562373095
Fx17_re_a2 0 x17_re_a2 V2 7.0710678118654755
Rp17_re_re_a2 0 x17_re_a2 1.7275207575091853e-10
Gp17_re_im_a2 0 x17_re_a2 x17_im_a2 0 521353584056.0092
Cx17_im_a2 x17_im_a2 0 1.0
Gp17_im_re_a2 0 x17_im_a2 x17_re_a2 0 -521353584056.0092
Rp17_im_im_a2 0 x17_im_a2 1.7275207575091853e-10
Cx18_re_a2 x18_re_a2 0 1.0
Gx18_re_a2 0 x18_re_a2 p2 0 0.1414213562373095
Fx18_re_a2 0 x18_re_a2 V2 7.0710678118654755
Rp18_re_re_a2 0 x18_re_a2 1.5115731395815119e-10
Gp18_re_im_a2 0 x18_re_a2 x18_im_a2 0 502816776247.36053
Cx18_im_a2 x18_im_a2 0 1.0
Gp18_im_re_a2 0 x18_im_a2 x18_re_a2 0 -502816776247.36053
Rp18_im_im_a2 0 x18_im_a2 1.5115731395815119e-10
Cx19_re_a2 x19_re_a2 0 1.0
Gx19_re_a2 0 x19_re_a2 p2 0 0.1414213562373095
Fx19_re_a2 0 x19_re_a2 V2 7.0710678118654755
Rp19_re_re_a2 0 x19_re_a2 1.9185802266543982e-10
Gp19_re_im_a2 0 x19_re_a2 x19_im_a2 0 514229488164.91797
Cx19_im_a2 x19_im_a2 0 1.0
Gp19_im_re_a2 0 x19_im_a2 x19_re_a2 0 -514229488164.91797
Rp19_im_im_a2 0 x19_im_a2 1.9185802266543982e-10
Cx20_re_a2 x20_re_a2 0 1.0
Gx20_re_a2 0 x20_re_a2 p2 0 0.1414213562373095
Fx20_re_a2 0 x20_re_a2 V2 7.0710678118654755
Rp20_re_re_a2 0 x20_re_a2 2.36531619046301e-10
Gp20_re_im_a2 0 x20_re_a2 x20_im_a2 0 507614835498.9133
Cx20_im_a2 x20_im_a2 0 1.0
Gp20_im_re_a2 0 x20_im_a2 x20_re_a2 0 -507614835498.9133
Rp20_im_im_a2 0 x20_im_a2 2.36531619046301e-10
Cx21_re_a2 x21_re_a2 0 1.0
Gx21_re_a2 0 x21_re_a2 p2 0 0.1414213562373095
Fx21_re_a2 0 x21_re_a2 V2 7.0710678118654755
Rp21_re_re_a2 0 x21_re_a2 2.3580923239344224e-08
Gp21_re_im_a2 0 x21_re_a2 x21_im_a2 0 509829715378.3856
Cx21_im_a2 x21_im_a2 0 1.0
Gp21_im_re_a2 0 x21_im_a2 x21_re_a2 0 -509829715378.3856
Rp21_im_im_a2 0 x21_im_a2 2.3580923239344224e-08
Cx22_re_a2 x22_re_a2 0 1.0
Gx22_re_a2 0 x22_re_a2 p2 0 0.1414213562373095
Fx22_re_a2 0 x22_re_a2 V2 7.0710678118654755
Rp22_re_re_a2 0 x22_re_a2 1.7126128646692673e-08
Gp22_re_im_a2 0 x22_re_a2 x22_im_a2 0 509168228853.63367
Cx22_im_a2 x22_im_a2 0 1.0
Gp22_im_re_a2 0 x22_im_a2 x22_re_a2 0 -509168228853.63367
Rp22_im_im_a2 0 x22_im_a2 1.7126128646692673e-08
.ENDS s_equivalent
