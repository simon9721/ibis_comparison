* EQUIVALENT CIRCUIT FOR VECTOR FITTED S-MATRIX
* Created using scikit-rf vectorFitting.py
*
.SUBCKT s_equivalent p1 p2
*
* Port network for port 1
V1 p1 s1 0
R1 s1 0 50.0
Gr1_1_1 0 s1 x1_a1 0 0.0
Gr2_1_1 0 s1 x2_a1 0 0.0
Gr3_re_1_1 0 s1 x3_re_a1 0 0.0
Gr3_im_1_1 0 s1 x3_im_a1 0 0.0
Gr4_1_1 0 s1 x4_a1 0 0.0
Gr5_1_1 0 s1 x5_a1 0 0.0
Gr6_1_1 0 s1 x6_a1 0 0.0
Gr7_1_1 0 s1 x7_a1 0 0.0
Gr8_1_1 0 s1 x8_a1 0 0.0
Gr9_1_1 0 s1 x9_a1 0 0.0
Gr10_1_1 0 s1 x10_a1 0 0.0
Gr11_1_1 0 s1 x11_a1 0 0.0
Gr12_1_1 0 s1 x12_a1 0 0.0
Gr13_1_1 0 s1 x13_a1 0 0.0
Gr14_1_1 0 s1 x14_a1 0 0.0
Gr15_1_1 0 s1 x15_a1 0 0.0
Gr16_1_1 0 s1 x16_a1 0 0.0
Gr17_1_1 0 s1 x17_a1 0 0.0
Gr18_re_1_1 0 s1 x18_re_a1 0 0.0
Gr18_im_1_1 0 s1 x18_im_a1 0 0.0
Gr19_re_1_1 0 s1 x19_re_a1 0 0.0
Gr19_im_1_1 0 s1 x19_im_a1 0 0.0
Gr20_re_1_1 0 s1 x20_re_a1 0 0.0
Gr20_im_1_1 0 s1 x20_im_a1 0 0.0
Gr1_1_2 0 s1 x1_a2 0 0.0
Gr2_1_2 0 s1 x2_a2 0 0.0
Gr3_re_1_2 0 s1 x3_re_a2 0 0.0
Gr3_im_1_2 0 s1 x3_im_a2 0 0.0
Gr4_1_2 0 s1 x4_a2 0 0.0
Gr5_1_2 0 s1 x5_a2 0 0.0
Gr6_1_2 0 s1 x6_a2 0 0.0
Gr7_1_2 0 s1 x7_a2 0 0.0
Gr8_1_2 0 s1 x8_a2 0 0.0
Gr9_1_2 0 s1 x9_a2 0 0.0
Gr10_1_2 0 s1 x10_a2 0 0.0
Gr11_1_2 0 s1 x11_a2 0 0.0
Gr12_1_2 0 s1 x12_a2 0 0.0
Gr13_1_2 0 s1 x13_a2 0 0.0
Gr14_1_2 0 s1 x14_a2 0 0.0
Gr15_1_2 0 s1 x15_a2 0 0.0
Gr16_1_2 0 s1 x16_a2 0 0.0
Gr17_1_2 0 s1 x17_a2 0 0.0
Gr18_re_1_2 0 s1 x18_re_a2 0 0.0
Gr18_im_1_2 0 s1 x18_im_a2 0 0.0
Gr19_re_1_2 0 s1 x19_re_a2 0 0.0
Gr19_im_1_2 0 s1 x19_im_a2 0 0.0
Gr20_re_1_2 0 s1 x20_re_a2 0 0.0
Gr20_im_1_2 0 s1 x20_im_a2 0 0.0
*
* State networks driven by port 1
Cx1_a1 x1_a1 0 1.0
Gx1_a1 0 x1_a1 p1 0 0.07071067811865475
Fx1_a1 0 x1_a1 V1 3.5355339059327378
Rp1_a1 0 x1_a1 9.731492495031104e-52
Cx2_a1 x2_a1 0 1.0
Gx2_a1 0 x2_a1 p1 0 0.07071067811865475
Fx2_a1 0 x2_a1 V1 3.5355339059327378
Rp2_a1 0 x2_a1 2.563302061644757e-29
Cx3_re_a1 x3_re_a1 0 1.0
Gx3_re_a1 0 x3_re_a1 p1 0 0.1414213562373095
Fx3_re_a1 0 x3_re_a1 V1 7.0710678118654755
Rp3_re_re_a1 0 x3_re_a1 2.5984960915469794e-22
Gp3_re_im_a1 0 x3_re_a1 x3_im_a1 0 3.3951376619416506e+21
Cx3_im_a1 x3_im_a1 0 1.0
Gp3_im_re_a1 0 x3_im_a1 x3_re_a1 0 -3.3951376619416506e+21
Rp3_im_im_a1 0 x3_im_a1 2.5984960915469794e-22
Cx4_a1 x4_a1 0 1.0
Gx4_a1 0 x4_a1 p1 0 0.07071067811865475
Fx4_a1 0 x4_a1 V1 3.5355339059327378
Rp4_a1 0 x4_a1 9.438448466907673e-19
Cx5_a1 x5_a1 0 1.0
Gx5_a1 0 x5_a1 p1 0 0.07071067811865475
Fx5_a1 0 x5_a1 V1 3.5355339059327378
Rp5_a1 0 x5_a1 4.151265894725325e-17
Cx6_a1 x6_a1 0 1.0
Gx6_a1 0 x6_a1 p1 0 0.07071067811865475
Fx6_a1 0 x6_a1 V1 3.5355339059327378
Rp6_a1 0 x6_a1 8.029471980426191e-16
Cx7_a1 x7_a1 0 1.0
Gx7_a1 0 x7_a1 p1 0 0.07071067811865475
Fx7_a1 0 x7_a1 V1 3.5355339059327378
Rp7_a1 0 x7_a1 2.4530422062891223e-15
Cx8_a1 x8_a1 0 1.0
Gx8_a1 0 x8_a1 p1 0 0.07071067811865475
Fx8_a1 0 x8_a1 V1 3.5355339059327378
Rp8_a1 0 x8_a1 4.2493883212515575e-15
Cx9_a1 x9_a1 0 1.0
Gx9_a1 0 x9_a1 p1 0 0.07071067811865475
Fx9_a1 0 x9_a1 V1 3.5355339059327378
Rp9_a1 0 x9_a1 2.026590738027068e-14
Cx10_a1 x10_a1 0 1.0
Gx10_a1 0 x10_a1 p1 0 0.07071067811865475
Fx10_a1 0 x10_a1 V1 3.5355339059327378
Rp10_a1 0 x10_a1 7.05792135498131e-14
Cx11_a1 x11_a1 0 1.0
Gx11_a1 0 x11_a1 p1 0 0.07071067811865475
Fx11_a1 0 x11_a1 V1 3.5355339059327378
Rp11_a1 0 x11_a1 2.096910307628609e-13
Cx12_a1 x12_a1 0 1.0
Gx12_a1 0 x12_a1 p1 0 0.07071067811865475
Fx12_a1 0 x12_a1 V1 3.5355339059327378
Rp12_a1 0 x12_a1 5.73370150191373e-13
Cx13_a1 x13_a1 0 1.0
Gx13_a1 0 x13_a1 p1 0 0.07071067811865475
Fx13_a1 0 x13_a1 V1 3.5355339059327378
Rp13_a1 0 x13_a1 1.5744636684574283e-12
Cx14_a1 x14_a1 0 1.0
Gx14_a1 0 x14_a1 p1 0 0.07071067811865475
Fx14_a1 0 x14_a1 V1 3.5355339059327378
Rp14_a1 0 x14_a1 3.6056547148209343e-12
Cx15_a1 x15_a1 0 1.0
Gx15_a1 0 x15_a1 p1 0 0.07071067811865475
Fx15_a1 0 x15_a1 V1 3.5355339059327378
Rp15_a1 0 x15_a1 7.779534436739522e-12
Cx16_a1 x16_a1 0 1.0
Gx16_a1 0 x16_a1 p1 0 0.07071067811865475
Fx16_a1 0 x16_a1 V1 3.5355339059327378
Rp16_a1 0 x16_a1 4.1041796947658686e-10
Cx17_a1 x17_a1 0 1.0
Gx17_a1 0 x17_a1 p1 0 0.07071067811865475
Fx17_a1 0 x17_a1 V1 3.5355339059327378
Rp17_a1 0 x17_a1 3.4776840354242753e-10
Cx18_re_a1 x18_re_a1 0 1.0
Gx18_re_a1 0 x18_re_a1 p1 0 0.1414213562373095
Fx18_re_a1 0 x18_re_a1 V1 7.0710678118654755
Rp18_re_re_a1 0 x18_re_a1 8.809381721967603e-09
Gp18_re_im_a1 0 x18_re_a1 x18_im_a1 0 1524663914.9269326
Cx18_im_a1 x18_im_a1 0 1.0
Gp18_im_re_a1 0 x18_im_a1 x18_re_a1 0 -1524663914.9269326
Rp18_im_im_a1 0 x18_im_a1 8.809381721967603e-09
Cx19_re_a1 x19_re_a1 0 1.0
Gx19_re_a1 0 x19_re_a1 p1 0 0.1414213562373095
Fx19_re_a1 0 x19_re_a1 V1 7.0710678118654755
Rp19_re_re_a1 0 x19_re_a1 3.1325594995957337e-09
Gp19_re_im_a1 0 x19_re_a1 x19_im_a1 0 439896492.9252838
Cx19_im_a1 x19_im_a1 0 1.0
Gp19_im_re_a1 0 x19_im_a1 x19_re_a1 0 -439896492.9252838
Rp19_im_im_a1 0 x19_im_a1 3.1325594995957337e-09
Cx20_re_a1 x20_re_a1 0 1.0
Gx20_re_a1 0 x20_re_a1 p1 0 0.1414213562373095
Fx20_re_a1 0 x20_re_a1 V1 7.0710678118654755
Rp20_re_re_a1 0 x20_re_a1 1.485349798620621e-08
Gp20_re_im_a1 0 x20_re_a1 x20_im_a1 0 135781302.93157616
Cx20_im_a1 x20_im_a1 0 1.0
Gp20_im_re_a1 0 x20_im_a1 x20_re_a1 0 -135781302.93157616
Rp20_im_im_a1 0 x20_im_a1 1.485349798620621e-08
*
* Port network for port 2
V2 p2 s2 0
R2 s2 0 50.0
Gd2_1 0 s2 p1 0 4.280351717511622e-10
Fd2_1 0 s2 V1 2.140175858755811e-08
Gr1_2_1 0 s2 x1_a1 0 3.270510060518052e+50
Gr2_2_1 0 s2 x2_a1 0 1.2418091795727569e+28
Gr3_re_2_1 0 s2 x3_re_a1 0 1.088173508357361e+21
Gr3_im_2_1 0 s2 x3_im_a1 0 -1.2335823757453102e+21
Gr4_2_1 0 s2 x4_a1 0 3.373527243223794e+17
Gr5_2_1 0 s2 x5_a1 0 7660253779394223.0
Gr6_2_1 0 s2 x6_a1 0 386157250263068.5
Gr7_2_1 0 s2 x7_a1 0 119949187104222.5
Gr8_2_1 0 s2 x8_a1 0 65101413624804.86
Gr9_2_1 0 s2 x9_a1 0 6846881940853.299
Gr10_2_1 0 s2 x10_a1 0 -1672751732253.8613
Gr11_2_1 0 s2 x11_a1 0 89580054083.83829
Gr12_2_1 0 s2 x12_a1 0 -1855293253.9869223
Gr13_2_1 0 s2 x13_a1 0 13327935.088794136
Gr14_2_1 0 s2 x14_a1 0 -89639.15859187515
Gr15_2_1 0 s2 x15_a1 0 245.0780555950329
Gr16_2_1 0 s2 x16_a1 0 -0.19787779678399423
Gr17_2_1 0 s2 x17_a1 0 0.12147437100174578
Gr18_re_2_1 0 s2 x18_re_a1 0 -0.015061161536949103
Gr18_im_2_1 0 s2 x18_im_a1 0 -0.015102296304278522
Gr19_re_2_1 0 s2 x19_re_a1 0 -0.21788666453698385
Gr19_im_2_1 0 s2 x19_im_a1 0 0.15392896315345048
Gr20_re_2_1 0 s2 x20_re_a1 0 0.27131542943929104
Gr20_im_2_1 0 s2 x20_im_a1 0 0.566164198071452
Gr1_2_2 0 s2 x1_a2 0 0.0
Gr2_2_2 0 s2 x2_a2 0 0.0
Gr3_re_2_2 0 s2 x3_re_a2 0 0.0
Gr3_im_2_2 0 s2 x3_im_a2 0 0.0
Gr4_2_2 0 s2 x4_a2 0 0.0
Gr5_2_2 0 s2 x5_a2 0 0.0
Gr6_2_2 0 s2 x6_a2 0 0.0
Gr7_2_2 0 s2 x7_a2 0 0.0
Gr8_2_2 0 s2 x8_a2 0 0.0
Gr9_2_2 0 s2 x9_a2 0 0.0
Gr10_2_2 0 s2 x10_a2 0 0.0
Gr11_2_2 0 s2 x11_a2 0 0.0
Gr12_2_2 0 s2 x12_a2 0 0.0
Gr13_2_2 0 s2 x13_a2 0 0.0
Gr14_2_2 0 s2 x14_a2 0 0.0
Gr15_2_2 0 s2 x15_a2 0 0.0
Gr16_2_2 0 s2 x16_a2 0 0.0
Gr17_2_2 0 s2 x17_a2 0 0.0
Gr18_re_2_2 0 s2 x18_re_a2 0 0.0
Gr18_im_2_2 0 s2 x18_im_a2 0 0.0
Gr19_re_2_2 0 s2 x19_re_a2 0 0.0
Gr19_im_2_2 0 s2 x19_im_a2 0 0.0
Gr20_re_2_2 0 s2 x20_re_a2 0 0.0
Gr20_im_2_2 0 s2 x20_im_a2 0 0.0
*
* State networks driven by port 2
Cx1_a2 x1_a2 0 1.0
Gx1_a2 0 x1_a2 p2 0 0.07071067811865475
Fx1_a2 0 x1_a2 V2 3.5355339059327378
Rp1_a2 0 x1_a2 9.731492495031104e-52
Cx2_a2 x2_a2 0 1.0
Gx2_a2 0 x2_a2 p2 0 0.07071067811865475
Fx2_a2 0 x2_a2 V2 3.5355339059327378
Rp2_a2 0 x2_a2 2.563302061644757e-29
Cx3_re_a2 x3_re_a2 0 1.0
Gx3_re_a2 0 x3_re_a2 p2 0 0.1414213562373095
Fx3_re_a2 0 x3_re_a2 V2 7.0710678118654755
Rp3_re_re_a2 0 x3_re_a2 2.5984960915469794e-22
Gp3_re_im_a2 0 x3_re_a2 x3_im_a2 0 3.3951376619416506e+21
Cx3_im_a2 x3_im_a2 0 1.0
Gp3_im_re_a2 0 x3_im_a2 x3_re_a2 0 -3.3951376619416506e+21
Rp3_im_im_a2 0 x3_im_a2 2.5984960915469794e-22
Cx4_a2 x4_a2 0 1.0
Gx4_a2 0 x4_a2 p2 0 0.07071067811865475
Fx4_a2 0 x4_a2 V2 3.5355339059327378
Rp4_a2 0 x4_a2 9.438448466907673e-19
Cx5_a2 x5_a2 0 1.0
Gx5_a2 0 x5_a2 p2 0 0.07071067811865475
Fx5_a2 0 x5_a2 V2 3.5355339059327378
Rp5_a2 0 x5_a2 4.151265894725325e-17
Cx6_a2 x6_a2 0 1.0
Gx6_a2 0 x6_a2 p2 0 0.07071067811865475
Fx6_a2 0 x6_a2 V2 3.5355339059327378
Rp6_a2 0 x6_a2 8.029471980426191e-16
Cx7_a2 x7_a2 0 1.0
Gx7_a2 0 x7_a2 p2 0 0.07071067811865475
Fx7_a2 0 x7_a2 V2 3.5355339059327378
Rp7_a2 0 x7_a2 2.4530422062891223e-15
Cx8_a2 x8_a2 0 1.0
Gx8_a2 0 x8_a2 p2 0 0.07071067811865475
Fx8_a2 0 x8_a2 V2 3.5355339059327378
Rp8_a2 0 x8_a2 4.2493883212515575e-15
Cx9_a2 x9_a2 0 1.0
Gx9_a2 0 x9_a2 p2 0 0.07071067811865475
Fx9_a2 0 x9_a2 V2 3.5355339059327378
Rp9_a2 0 x9_a2 2.026590738027068e-14
Cx10_a2 x10_a2 0 1.0
Gx10_a2 0 x10_a2 p2 0 0.07071067811865475
Fx10_a2 0 x10_a2 V2 3.5355339059327378
Rp10_a2 0 x10_a2 7.05792135498131e-14
Cx11_a2 x11_a2 0 1.0
Gx11_a2 0 x11_a2 p2 0 0.07071067811865475
Fx11_a2 0 x11_a2 V2 3.5355339059327378
Rp11_a2 0 x11_a2 2.096910307628609e-13
Cx12_a2 x12_a2 0 1.0
Gx12_a2 0 x12_a2 p2 0 0.07071067811865475
Fx12_a2 0 x12_a2 V2 3.5355339059327378
Rp12_a2 0 x12_a2 5.73370150191373e-13
Cx13_a2 x13_a2 0 1.0
Gx13_a2 0 x13_a2 p2 0 0.07071067811865475
Fx13_a2 0 x13_a2 V2 3.5355339059327378
Rp13_a2 0 x13_a2 1.5744636684574283e-12
Cx14_a2 x14_a2 0 1.0
Gx14_a2 0 x14_a2 p2 0 0.07071067811865475
Fx14_a2 0 x14_a2 V2 3.5355339059327378
Rp14_a2 0 x14_a2 3.6056547148209343e-12
Cx15_a2 x15_a2 0 1.0
Gx15_a2 0 x15_a2 p2 0 0.07071067811865475
Fx15_a2 0 x15_a2 V2 3.5355339059327378
Rp15_a2 0 x15_a2 7.779534436739522e-12
Cx16_a2 x16_a2 0 1.0
Gx16_a2 0 x16_a2 p2 0 0.07071067811865475
Fx16_a2 0 x16_a2 V2 3.5355339059327378
Rp16_a2 0 x16_a2 4.1041796947658686e-10
Cx17_a2 x17_a2 0 1.0
Gx17_a2 0 x17_a2 p2 0 0.07071067811865475
Fx17_a2 0 x17_a2 V2 3.5355339059327378
Rp17_a2 0 x17_a2 3.4776840354242753e-10
Cx18_re_a2 x18_re_a2 0 1.0
Gx18_re_a2 0 x18_re_a2 p2 0 0.1414213562373095
Fx18_re_a2 0 x18_re_a2 V2 7.0710678118654755
Rp18_re_re_a2 0 x18_re_a2 8.809381721967603e-09
Gp18_re_im_a2 0 x18_re_a2 x18_im_a2 0 1524663914.9269326
Cx18_im_a2 x18_im_a2 0 1.0
Gp18_im_re_a2 0 x18_im_a2 x18_re_a2 0 -1524663914.9269326
Rp18_im_im_a2 0 x18_im_a2 8.809381721967603e-09
Cx19_re_a2 x19_re_a2 0 1.0
Gx19_re_a2 0 x19_re_a2 p2 0 0.1414213562373095
Fx19_re_a2 0 x19_re_a2 V2 7.0710678118654755
Rp19_re_re_a2 0 x19_re_a2 3.1325594995957337e-09
Gp19_re_im_a2 0 x19_re_a2 x19_im_a2 0 439896492.9252838
Cx19_im_a2 x19_im_a2 0 1.0
Gp19_im_re_a2 0 x19_im_a2 x19_re_a2 0 -439896492.9252838
Rp19_im_im_a2 0 x19_im_a2 3.1325594995957337e-09
Cx20_re_a2 x20_re_a2 0 1.0
Gx20_re_a2 0 x20_re_a2 p2 0 0.1414213562373095
Fx20_re_a2 0 x20_re_a2 V2 7.0710678118654755
Rp20_re_re_a2 0 x20_re_a2 1.485349798620621e-08
Gp20_re_im_a2 0 x20_re_a2 x20_im_a2 0 135781302.93157616
Cx20_im_a2 x20_im_a2 0 1.0
Gp20_im_re_a2 0 x20_im_a2 x20_re_a2 0 -135781302.93157616
Rp20_im_im_a2 0 x20_im_a2 1.485349798620621e-08
.ENDS s_equivalent
