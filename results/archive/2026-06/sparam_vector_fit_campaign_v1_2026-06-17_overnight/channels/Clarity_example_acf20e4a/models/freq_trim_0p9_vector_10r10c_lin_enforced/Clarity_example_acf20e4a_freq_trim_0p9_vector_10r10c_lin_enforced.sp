* EQUIVALENT CIRCUIT FOR VECTOR FITTED S-MATRIX
* Created using scikit-rf vectorFitting.py
*
.SUBCKT s_equivalent p1 p2
*
* Port network for port 1
V1 p1 s1 0
R1 s1 0 50.0
Gd1_1 0 s1 p1 0 55.01372076654411
Fd1_1 0 s1 V1 2750.6860383272056
Gr1_re_1_1 0 s1 x1_re_a1 0 -3430158356961705.5
Gr1_im_1_1 0 s1 x1_im_a1 0 559119397872542.4
Gr2_1_1 0 s1 x2_a1 0 -1.131670625916459e+18
Gr3_re_1_1 0 s1 x3_re_a1 0 673358311226102.5
Gr3_im_1_1 0 s1 x3_im_a1 0 -2370585657873690.0
Gr4_re_1_1 0 s1 x4_re_a1 0 4733658255267114.0
Gr4_im_1_1 0 s1 x4_im_a1 0 2.251021397276369e+16
Gr5_1_1 0 s1 x5_a1 0 1.1479578970111142e+19
Gr6_re_1_1 0 s1 x6_re_a1 0 -2.343953483378069e+17
Gr6_im_1_1 0 s1 x6_im_a1 0 6.5085153640883384e+16
Gr7_re_1_1 0 s1 x7_re_a1 0 1.0826777770010993e+18
Gr7_im_1_1 0 s1 x7_im_a1 0 -2.7465000955214195e+17
Gr8_1_1 0 s1 x8_a1 0 1.003173784451275e+22
Gr9_1_1 0 s1 x9_a1 0 -2.9000864687889695e+22
Gr10_1_1 0 s1 x10_a1 0 -1.8768503981096284e+21
Gr11_1_1 0 s1 x11_a1 0 -1.375972605010465e+22
Gr12_1_1 0 s1 x12_a1 0 3.5308937339580674e+21
Gr13_re_1_1 0 s1 x13_re_a1 0 1.1511927133330955e+22
Gr13_im_1_1 0 s1 x13_im_a1 0 1.0854044864656972e+23
Gr14_1_1 0 s1 x14_a1 0 4.232226999515717e+22
Gr15_1_1 0 s1 x15_a1 0 -3.3017393163428237e+22
Gr16_1_1 0 s1 x16_a1 0 2.3278471836438037e+22
Gr17_1_1 0 s1 x17_a1 0 2.4094688824312526e+21
Gr18_1_1 0 s1 x18_a1 0 -1.3756736093022566e+21
Gr19_1_1 0 s1 x19_a1 0 1.3052852173524736e+18
Gr20_1_1 0 s1 x20_a1 0 -2.8839195392671035e+22
Gr21_1_1 0 s1 x21_a1 0 3.6602452788552857e+21
Gr22_1_1 0 s1 x22_a1 0 -1.6512210740836353e+21
Gr23_1_1 0 s1 x23_a1 0 -2.7970185416059837e+20
Gr24_1_1 0 s1 x24_a1 0 1.530330530916087e+21
Gd1_2 0 s1 p2 0 45.667141007701595
Fd1_2 0 s1 V2 2283.3570503850797
Gr1_re_1_2 0 s1 x1_re_a2 0 -2847402942465956.0
Gr1_im_1_2 0 s1 x1_im_a2 0 464115625109083.1
Gr2_1_2 0 s1 x2_a2 0 -9.394107676046532e+17
Gr3_re_1_2 0 s1 x3_re_a2 0 558946001211621.56
Gr3_im_1_2 0 s1 x3_im_a2 0 -1967846845288663.0
Gr4_re_1_2 0 s1 x4_re_a2 0 3929470896876487.0
Gr4_im_1_2 0 s1 x4_im_a2 0 1.8685937176599612e+16
Gr5_1_2 0 s1 x5_a2 0 9.52932248725125e+18
Gr6_re_1_2 0 s1 x6_re_a2 0 -1.9457465117660614e+17
Gr6_im_1_2 0 s1 x6_im_a2 0 5.402684215639573e+16
Gr7_re_1_2 0 s1 x7_re_a2 0 8.987446325469364e+17
Gr7_im_1_2 0 s1 x7_im_a2 0 -2.2798735979439866e+17
Gr8_1_2 0 s1 x8_a2 0 8.327430665845408e+21
Gr9_1_2 0 s1 x9_a2 0 -2.4073818917015527e+22
Gr10_1_2 0 s1 x10_a2 0 -1.5579928986815231e+21
Gr11_1_2 0 s1 x11_a2 0 -1.1422079891884873e+22
Gr12_1_2 0 s1 x12_a2 0 2.931042498158032e+21
Gr13_re_1_2 0 s1 x13_re_a2 0 9.556091540356662e+21
Gr13_im_1_2 0 s1 x13_im_a2 0 9.00997604017243e+22
Gr14_1_2 0 s1 x14_a2 0 3.5132021128432114e+22
Gr15_1_2 0 s1 x15_a2 0 -2.7407964150797043e+22
Gr16_1_2 0 s1 x16_a2 0 1.9323607057945577e+22
Gr17_1_2 0 s1 x17_a2 0 2.000112057454343e+21
Gr18_1_2 0 s1 x18_a2 0 -1.1419404166372995e+21
Gr19_1_2 0 s1 x19_a2 0 1.0834962623651314e+18
Gr20_1_2 0 s1 x20_a2 0 -2.3939516140651735e+22
Gr21_1_2 0 s1 x21_a2 0 3.038379852598647e+21
Gr22_1_2 0 s1 x22_a2 0 -1.3706897341403085e+21
Gr23_1_2 0 s1 x23_a2 0 -2.3218007156763145e+20
Gr24_1_2 0 s1 x24_a2 0 1.2703207268326517e+21
*
* State networks driven by port 1
Cx1_re_a1 x1_re_a1 0 1.0
Gx1_re_a1 0 x1_re_a1 p1 0 0.1414213562373095
Fx1_re_a1 0 x1_re_a1 V1 7.0710678118654755
Rp1_re_re_a1 0 x1_re_a1 3.705675403157173e-11
Gp1_re_im_a1 0 x1_re_a1 x1_im_a1 0 31271884609.506916
Cx1_im_a1 x1_im_a1 0 1.0
Gp1_im_re_a1 0 x1_im_a1 x1_re_a1 0 -31271884609.506916
Rp1_im_im_a1 0 x1_im_a1 3.705675403157173e-11
Cx2_a1 x2_a1 0 1.0
Gx2_a1 0 x2_a1 p1 0 0.07071067811865475
Fx2_a1 0 x2_a1 V1 3.5355339059327378
Rp2_a1 0 x2_a1 4.225478865345733e-11
Cx3_re_a1 x3_re_a1 0 1.0
Gx3_re_a1 0 x3_re_a1 p1 0 0.1414213562373095
Fx3_re_a1 0 x3_re_a1 V1 7.0710678118654755
Rp3_re_re_a1 0 x3_re_a1 1.6737299963949526e-10
Gp3_re_im_a1 0 x3_re_a1 x3_im_a1 0 17577771648.025005
Cx3_im_a1 x3_im_a1 0 1.0
Gp3_im_re_a1 0 x3_im_a1 x3_re_a1 0 -17577771648.025005
Rp3_im_im_a1 0 x3_im_a1 1.6737299963949526e-10
Cx4_re_a1 x4_re_a1 0 1.0
Gx4_re_a1 0 x4_re_a1 p1 0 0.1414213562373095
Fx4_re_a1 0 x4_re_a1 V1 7.0710678118654755
Rp4_re_re_a1 0 x4_re_a1 1.1863659715575e-10
Gp4_re_im_a1 0 x4_re_a1 x4_im_a1 0 16577604487.587902
Cx4_im_a1 x4_im_a1 0 1.0
Gp4_im_re_a1 0 x4_im_a1 x4_re_a1 0 -16577604487.587902
Rp4_im_im_a1 0 x4_im_a1 1.1863659715575e-10
Cx5_a1 x5_a1 0 1.0
Gx5_a1 0 x5_a1 p1 0 0.07071067811865475
Fx5_a1 0 x5_a1 V1 3.5355339059327378
Rp5_a1 0 x5_a1 6.657852698251186e-11
Cx6_re_a1 x6_re_a1 0 1.0
Gx6_re_a1 0 x6_re_a1 p1 0 0.1414213562373095
Fx6_re_a1 0 x6_re_a1 V1 7.0710678118654755
Rp6_re_re_a1 0 x6_re_a1 1.3536146409470355e-10
Gp6_re_im_a1 0 x6_re_a1 x6_im_a1 0 10464460045.138655
Cx6_im_a1 x6_im_a1 0 1.0
Gp6_im_re_a1 0 x6_im_a1 x6_re_a1 0 -10464460045.138655
Rp6_im_im_a1 0 x6_im_a1 1.3536146409470355e-10
Cx7_re_a1 x7_re_a1 0 1.0
Gx7_re_a1 0 x7_re_a1 p1 0 0.1414213562373095
Fx7_re_a1 0 x7_re_a1 V1 7.0710678118654755
Rp7_re_re_a1 0 x7_re_a1 1.122821918638936e-10
Gp7_re_im_a1 0 x7_re_a1 x7_im_a1 0 9320269150.92845
Cx7_im_a1 x7_im_a1 0 1.0
Gp7_im_re_a1 0 x7_im_a1 x7_re_a1 0 -9320269150.92845
Rp7_im_im_a1 0 x7_im_a1 1.122821918638936e-10
Cx8_a1 x8_a1 0 1.0
Gx8_a1 0 x8_a1 p1 0 0.07071067811865475
Fx8_a1 0 x8_a1 V1 3.5355339059327378
Rp8_a1 0 x8_a1 1.6683497661761483e-10
Cx9_a1 x9_a1 0 1.0
Gx9_a1 0 x9_a1 p1 0 0.07071067811865475
Fx9_a1 0 x9_a1 V1 3.5355339059327378
Rp9_a1 0 x9_a1 2.7488914580782343e-10
Cx10_a1 x10_a1 0 1.0
Gx10_a1 0 x10_a1 p1 0 0.07071067811865475
Fx10_a1 0 x10_a1 V1 3.5355339059327378
Rp10_a1 0 x10_a1 1.4578135398088027e-10
Cx11_a1 x11_a1 0 1.0
Gx11_a1 0 x11_a1 p1 0 0.07071067811865475
Fx11_a1 0 x11_a1 V1 3.5355339059327378
Rp11_a1 0 x11_a1 1.7533502447660499e-10
Cx12_a1 x12_a1 0 1.0
Gx12_a1 0 x12_a1 p1 0 0.07071067811865475
Fx12_a1 0 x12_a1 V1 3.5355339059327378
Rp12_a1 0 x12_a1 1.670926048793339e-10
Cx13_re_a1 x13_re_a1 0 1.0
Gx13_re_a1 0 x13_re_a1 p1 0 0.1414213562373095
Fx13_re_a1 0 x13_re_a1 V1 7.0710678118654755
Rp13_re_re_a1 0 x13_re_a1 5.894879321446036e-10
Gp13_re_im_a1 0 x13_re_a1 x13_im_a1 0 17979144.418219775
Cx13_im_a1 x13_im_a1 0 1.0
Gp13_im_re_a1 0 x13_im_a1 x13_re_a1 0 -17979144.418219775
Rp13_im_im_a1 0 x13_im_a1 5.894879321446036e-10
Cx14_a1 x14_a1 0 1.0
Gx14_a1 0 x14_a1 p1 0 0.07071067811865475
Fx14_a1 0 x14_a1 V1 3.5355339059327378
Rp14_a1 0 x14_a1 2.6230185293835904e-10
Cx15_a1 x15_a1 0 1.0
Gx15_a1 0 x15_a1 p1 0 0.07071067811865475
Fx15_a1 0 x15_a1 V1 3.5355339059327378
Rp15_a1 0 x15_a1 2.778108444076751e-10
Cx16_a1 x16_a1 0 1.0
Gx16_a1 0 x16_a1 p1 0 0.07071067811865475
Fx16_a1 0 x16_a1 V1 3.5355339059327378
Rp16_a1 0 x16_a1 3.035638142220406e-10
Cx17_a1 x17_a1 0 1.0
Gx17_a1 0 x17_a1 p1 0 0.07071067811865475
Fx17_a1 0 x17_a1 V1 3.5355339059327378
Rp17_a1 0 x17_a1 9.337076375351446e-10
Cx18_a1 x18_a1 0 1.0
Gx18_a1 0 x18_a1 p1 0 0.07071067811865475
Fx18_a1 0 x18_a1 V1 3.5355339059327378
Rp18_a1 0 x18_a1 2.760509244653784e-09
Cx19_a1 x19_a1 0 1.0
Gx19_a1 0 x19_a1 p1 0 0.07071067811865475
Fx19_a1 0 x19_a1 V1 3.5355339059327378
Rp19_a1 0 x19_a1 6.920251826518458e-09
Cx20_a1 x20_a1 0 1.0
Gx20_a1 0 x20_a1 p1 0 0.07071067811865475
Fx20_a1 0 x20_a1 V1 3.5355339059327378
Rp20_a1 0 x20_a1 5.337178339985515e-10
Cx21_a1 x21_a1 0 1.0
Gx21_a1 0 x21_a1 p1 0 0.07071067811865475
Fx21_a1 0 x21_a1 V1 3.5355339059327378
Rp21_a1 0 x21_a1 5.542085623824842e-10
Cx22_a1 x22_a1 0 1.0
Gx22_a1 0 x22_a1 p1 0 0.07071067811865475
Fx22_a1 0 x22_a1 V1 3.5355339059327378
Rp22_a1 0 x22_a1 9.2840010075086e-10
Cx23_a1 x23_a1 0 1.0
Gx23_a1 0 x23_a1 p1 0 0.07071067811865475
Fx23_a1 0 x23_a1 V1 3.5355339059327378
Rp23_a1 0 x23_a1 1.8066863489259432e-09
Cx24_a1 x24_a1 0 1.0
Gx24_a1 0 x24_a1 p1 0 0.07071067811865475
Fx24_a1 0 x24_a1 V1 3.5355339059327378
Rp24_a1 0 x24_a1 2.6951812542755706e-09
*
* Port network for port 2
V2 p2 s2 0
R2 s2 0 50.0
Gd2_1 0 s2 p1 0 45.667141007701595
Fd2_1 0 s2 V1 2283.3570503850797
Gr1_re_2_1 0 s2 x1_re_a1 0 -2847403192243214.0
Gr1_im_2_1 0 s2 x1_im_a1 0 464115414865065.5
Gr2_2_1 0 s2 x2_a1 0 -9.394109456391766e+17
Gr3_re_2_1 0 s2 x3_re_a1 0 558946575336261.9
Gr3_im_2_1 0 s2 x3_im_a1 0 -1967846971181843.0
Gr4_re_2_1 0 s2 x4_re_a1 0 3929467370080074.0
Gr4_im_2_1 0 s2 x4_im_a1 0 1.868594089963625e+16
Gr5_2_1 0 s2 x5_a1 0 9.529325206175803e+18
Gr6_re_2_1 0 s2 x6_re_a1 0 -1.94574710746046e+17
Gr6_im_2_1 0 s2 x6_im_a1 0 5.4026808748953624e+16
Gr7_re_2_1 0 s2 x7_re_a1 0 8.987449147691139e+17
Gr7_im_2_1 0 s2 x7_im_a1 0 -2.2798723176883728e+17
Gr8_2_1 0 s2 x8_a1 0 8.327437914454504e+21
Gr9_2_1 0 s2 x9_a1 0 -2.407384258327439e+22
Gr10_2_1 0 s2 x10_a1 0 -1.5579937613770672e+21
Gr11_2_1 0 s2 x11_a1 0 -1.142208715734126e+22
Gr12_2_1 0 s2 x12_a1 0 2.931042127901453e+21
Gr13_re_2_1 0 s2 x13_re_a1 0 9.5561070522173e+21
Gr13_im_2_1 0 s2 x13_im_a1 0 9.009992285579947e+22
Gr14_2_1 0 s2 x14_a1 0 3.5132052695105594e+22
Gr15_2_1 0 s2 x15_a1 0 -2.7407988671096233e+22
Gr16_2_1 0 s2 x16_a1 0 1.932362652155835e+22
Gr17_2_1 0 s2 x17_a1 0 2.0001138259694487e+21
Gr18_2_1 0 s2 x18_a1 0 -1.1419485733210464e+21
Gr19_2_1 0 s2 x19_a1 0 1.083514156496075e+18
Gr20_2_1 0 s2 x20_a1 0 -2.3939555796455392e+22
Gr21_2_1 0 s2 x21_a1 0 3.038385501310219e+21
Gr22_2_1 0 s2 x22_a1 0 -1.3706897379121006e+21
Gr23_2_1 0 s2 x23_a1 0 -2.3218118386557914e+20
Gr24_2_1 0 s2 x24_a1 0 1.270329599639148e+21
Gd2_2 0 s2 p2 0 55.00752544309232
Fd2_2 0 s2 V2 2750.376272154616
Gr1_re_2_2 0 s2 x1_re_a2 0 -3429771957737681.5
Gr1_im_2_2 0 s2 x1_im_a2 0 559056572620622.25
Gr2_2_2 0 s2 x2_a2 0 -1.1315430840593172e+18
Gr3_re_2_2 0 s2 x3_re_a2 0 673282170723524.1
Gr3_im_2_2 0 s2 x3_im_a2 0 -2370318652764438.0
Gr4_re_2_2 0 s2 x4_re_a2 0 4733127274426873.0
Gr4_im_2_2 0 s2 x4_im_a2 0 2.2507677127550584e+16
Gr5_2_2 0 s2 x5_a2 0 1.1478284578236578e+19
Gr6_re_2_2 0 s2 x6_re_a2 0 -2.343689215293139e+17
Gr6_im_2_2 0 s2 x6_im_a2 0 6.507784924106026e+16
Gr7_re_2_2 0 s2 x7_re_a2 0 1.0825556964408374e+18
Gr7_im_2_2 0 s2 x7_im_a2 0 -2.7461917872933354e+17
Gr8_2_2 0 s2 x8_a2 0 1.0030602662928697e+22
Gr9_2_2 0 s2 x9_a2 0 -2.8997580780621925e+22
Gr10_2_2 0 s2 x10_a2 0 -1.8766384495470146e+21
Gr11_2_2 0 s2 x11_a2 0 -1.375817141808872e+22
Gr12_2_2 0 s2 x12_a2 0 3.5304967893919565e+21
Gr13_re_2_2 0 s2 x13_re_a2 0 1.151061805123034e+22
Gr13_im_2_2 0 s2 x13_im_a2 0 1.0852809112050604e+23
Gr14_2_2 0 s2 x14_a2 0 4.231748027427312e+22
Gr15_2_2 0 s2 x15_a2 0 -3.3013656600898794e+22
Gr16_2_2 0 s2 x16_a2 0 2.327583548923358e+22
Gr17_2_2 0 s2 x17_a2 0 2.409196243600189e+21
Gr18_2_2 0 s2 x18_a2 0 -1.375511383257945e+21
Gr19_2_2 0 s2 x19_a2 0 1.3051219550874565e+18
Gr20_2_2 0 s2 x20_a2 0 -2.883591520510184e+22
Gr21_2_2 0 s2 x21_a2 0 3.6598283981729526e+21
Gr22_2_2 0 s2 x22_a2 0 -1.6510353406939478e+21
Gr23_2_2 0 s2 x23_a2 0 -2.7966937246394306e+20
Gr24_2_2 0 s2 x24_a2 0 1.5301502516717402e+21
*
* State networks driven by port 2
Cx1_re_a2 x1_re_a2 0 1.0
Gx1_re_a2 0 x1_re_a2 p2 0 0.1414213562373095
Fx1_re_a2 0 x1_re_a2 V2 7.0710678118654755
Rp1_re_re_a2 0 x1_re_a2 3.705675403157173e-11
Gp1_re_im_a2 0 x1_re_a2 x1_im_a2 0 31271884609.506916
Cx1_im_a2 x1_im_a2 0 1.0
Gp1_im_re_a2 0 x1_im_a2 x1_re_a2 0 -31271884609.506916
Rp1_im_im_a2 0 x1_im_a2 3.705675403157173e-11
Cx2_a2 x2_a2 0 1.0
Gx2_a2 0 x2_a2 p2 0 0.07071067811865475
Fx2_a2 0 x2_a2 V2 3.5355339059327378
Rp2_a2 0 x2_a2 4.225478865345733e-11
Cx3_re_a2 x3_re_a2 0 1.0
Gx3_re_a2 0 x3_re_a2 p2 0 0.1414213562373095
Fx3_re_a2 0 x3_re_a2 V2 7.0710678118654755
Rp3_re_re_a2 0 x3_re_a2 1.6737299963949526e-10
Gp3_re_im_a2 0 x3_re_a2 x3_im_a2 0 17577771648.025005
Cx3_im_a2 x3_im_a2 0 1.0
Gp3_im_re_a2 0 x3_im_a2 x3_re_a2 0 -17577771648.025005
Rp3_im_im_a2 0 x3_im_a2 1.6737299963949526e-10
Cx4_re_a2 x4_re_a2 0 1.0
Gx4_re_a2 0 x4_re_a2 p2 0 0.1414213562373095
Fx4_re_a2 0 x4_re_a2 V2 7.0710678118654755
Rp4_re_re_a2 0 x4_re_a2 1.1863659715575e-10
Gp4_re_im_a2 0 x4_re_a2 x4_im_a2 0 16577604487.587902
Cx4_im_a2 x4_im_a2 0 1.0
Gp4_im_re_a2 0 x4_im_a2 x4_re_a2 0 -16577604487.587902
Rp4_im_im_a2 0 x4_im_a2 1.1863659715575e-10
Cx5_a2 x5_a2 0 1.0
Gx5_a2 0 x5_a2 p2 0 0.07071067811865475
Fx5_a2 0 x5_a2 V2 3.5355339059327378
Rp5_a2 0 x5_a2 6.657852698251186e-11
Cx6_re_a2 x6_re_a2 0 1.0
Gx6_re_a2 0 x6_re_a2 p2 0 0.1414213562373095
Fx6_re_a2 0 x6_re_a2 V2 7.0710678118654755
Rp6_re_re_a2 0 x6_re_a2 1.3536146409470355e-10
Gp6_re_im_a2 0 x6_re_a2 x6_im_a2 0 10464460045.138655
Cx6_im_a2 x6_im_a2 0 1.0
Gp6_im_re_a2 0 x6_im_a2 x6_re_a2 0 -10464460045.138655
Rp6_im_im_a2 0 x6_im_a2 1.3536146409470355e-10
Cx7_re_a2 x7_re_a2 0 1.0
Gx7_re_a2 0 x7_re_a2 p2 0 0.1414213562373095
Fx7_re_a2 0 x7_re_a2 V2 7.0710678118654755
Rp7_re_re_a2 0 x7_re_a2 1.122821918638936e-10
Gp7_re_im_a2 0 x7_re_a2 x7_im_a2 0 9320269150.92845
Cx7_im_a2 x7_im_a2 0 1.0
Gp7_im_re_a2 0 x7_im_a2 x7_re_a2 0 -9320269150.92845
Rp7_im_im_a2 0 x7_im_a2 1.122821918638936e-10
Cx8_a2 x8_a2 0 1.0
Gx8_a2 0 x8_a2 p2 0 0.07071067811865475
Fx8_a2 0 x8_a2 V2 3.5355339059327378
Rp8_a2 0 x8_a2 1.6683497661761483e-10
Cx9_a2 x9_a2 0 1.0
Gx9_a2 0 x9_a2 p2 0 0.07071067811865475
Fx9_a2 0 x9_a2 V2 3.5355339059327378
Rp9_a2 0 x9_a2 2.7488914580782343e-10
Cx10_a2 x10_a2 0 1.0
Gx10_a2 0 x10_a2 p2 0 0.07071067811865475
Fx10_a2 0 x10_a2 V2 3.5355339059327378
Rp10_a2 0 x10_a2 1.4578135398088027e-10
Cx11_a2 x11_a2 0 1.0
Gx11_a2 0 x11_a2 p2 0 0.07071067811865475
Fx11_a2 0 x11_a2 V2 3.5355339059327378
Rp11_a2 0 x11_a2 1.7533502447660499e-10
Cx12_a2 x12_a2 0 1.0
Gx12_a2 0 x12_a2 p2 0 0.07071067811865475
Fx12_a2 0 x12_a2 V2 3.5355339059327378
Rp12_a2 0 x12_a2 1.670926048793339e-10
Cx13_re_a2 x13_re_a2 0 1.0
Gx13_re_a2 0 x13_re_a2 p2 0 0.1414213562373095
Fx13_re_a2 0 x13_re_a2 V2 7.0710678118654755
Rp13_re_re_a2 0 x13_re_a2 5.894879321446036e-10
Gp13_re_im_a2 0 x13_re_a2 x13_im_a2 0 17979144.418219775
Cx13_im_a2 x13_im_a2 0 1.0
Gp13_im_re_a2 0 x13_im_a2 x13_re_a2 0 -17979144.418219775
Rp13_im_im_a2 0 x13_im_a2 5.894879321446036e-10
Cx14_a2 x14_a2 0 1.0
Gx14_a2 0 x14_a2 p2 0 0.07071067811865475
Fx14_a2 0 x14_a2 V2 3.5355339059327378
Rp14_a2 0 x14_a2 2.6230185293835904e-10
Cx15_a2 x15_a2 0 1.0
Gx15_a2 0 x15_a2 p2 0 0.07071067811865475
Fx15_a2 0 x15_a2 V2 3.5355339059327378
Rp15_a2 0 x15_a2 2.778108444076751e-10
Cx16_a2 x16_a2 0 1.0
Gx16_a2 0 x16_a2 p2 0 0.07071067811865475
Fx16_a2 0 x16_a2 V2 3.5355339059327378
Rp16_a2 0 x16_a2 3.035638142220406e-10
Cx17_a2 x17_a2 0 1.0
Gx17_a2 0 x17_a2 p2 0 0.07071067811865475
Fx17_a2 0 x17_a2 V2 3.5355339059327378
Rp17_a2 0 x17_a2 9.337076375351446e-10
Cx18_a2 x18_a2 0 1.0
Gx18_a2 0 x18_a2 p2 0 0.07071067811865475
Fx18_a2 0 x18_a2 V2 3.5355339059327378
Rp18_a2 0 x18_a2 2.760509244653784e-09
Cx19_a2 x19_a2 0 1.0
Gx19_a2 0 x19_a2 p2 0 0.07071067811865475
Fx19_a2 0 x19_a2 V2 3.5355339059327378
Rp19_a2 0 x19_a2 6.920251826518458e-09
Cx20_a2 x20_a2 0 1.0
Gx20_a2 0 x20_a2 p2 0 0.07071067811865475
Fx20_a2 0 x20_a2 V2 3.5355339059327378
Rp20_a2 0 x20_a2 5.337178339985515e-10
Cx21_a2 x21_a2 0 1.0
Gx21_a2 0 x21_a2 p2 0 0.07071067811865475
Fx21_a2 0 x21_a2 V2 3.5355339059327378
Rp21_a2 0 x21_a2 5.542085623824842e-10
Cx22_a2 x22_a2 0 1.0
Gx22_a2 0 x22_a2 p2 0 0.07071067811865475
Fx22_a2 0 x22_a2 V2 3.5355339059327378
Rp22_a2 0 x22_a2 9.2840010075086e-10
Cx23_a2 x23_a2 0 1.0
Gx23_a2 0 x23_a2 p2 0 0.07071067811865475
Fx23_a2 0 x23_a2 V2 3.5355339059327378
Rp23_a2 0 x23_a2 1.8066863489259432e-09
Cx24_a2 x24_a2 0 1.0
Gx24_a2 0 x24_a2 p2 0 0.07071067811865475
Fx24_a2 0 x24_a2 V2 3.5355339059327378
Rp24_a2 0 x24_a2 2.6951812542755706e-09
.ENDS s_equivalent
