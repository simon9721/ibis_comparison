* EQUIVALENT CIRCUIT FOR VECTOR FITTED S-MATRIX
* Created using scikit-rf vectorFitting.py
*
.SUBCKT s_equivalent p1 p2
*
* Port network for port 1
V1 p1 s1 0
R1 s1 0 50.0
Gd1_1 0 s1 p1 0 5.761632845902575
Fd1_1 0 s1 V1 288.0816422951288
Gr1_1_1 0 s1 x1_a1 0 -4374893541586048.0
Gr2_re_1_1 0 s1 x2_re_a1 0 -20175967264555.535
Gr2_im_1_1 0 s1 x2_im_a1 0 -310759556133626.06
Gr3_re_1_1 0 s1 x3_re_a1 0 306471955798330.9
Gr3_im_1_1 0 s1 x3_im_a1 0 -29690308756590.633
Gr4_re_1_1 0 s1 x4_re_a1 0 -1.845477133843287e+17
Gr4_im_1_1 0 s1 x4_im_a1 0 -3.551313498305526e+16
Gr5_re_1_1 0 s1 x5_re_a1 0 5.621009870609396e+17
Gr5_im_1_1 0 s1 x5_im_a1 0 -1.9771345534605648e+17
Gr6_re_1_1 0 s1 x6_re_a1 0 -4.3644099590006e+16
Gr6_im_1_1 0 s1 x6_im_a1 0 2.213051484514987e+16
Gr7_1_1 0 s1 x7_a1 0 -1.949463558592691e+22
Gr8_re_1_1 0 s1 x8_re_a1 0 -2.953204281295873e+19
Gr8_im_1_1 0 s1 x8_im_a1 0 1.0244550232256678e+19
Gr9_1_1 0 s1 x9_a1 0 3.158992913282382e+21
Gr10_1_1 0 s1 x10_a1 0 -5.496751546583354e+21
Gr11_1_1 0 s1 x11_a1 0 1.9478506887902403e+22
Gr12_1_1 0 s1 x12_a1 0 -2.399494082578376e+21
Gr13_1_1 0 s1 x13_a1 0 -6.063138584334535e+21
Gr14_1_1 0 s1 x14_a1 0 7.959139494048239e+21
Gr15_1_1 0 s1 x15_a1 0 6.372284215718188e+20
Gr16_1_1 0 s1 x16_a1 0 1.1093584644753359e+21
Gr17_re_1_1 0 s1 x17_re_a1 0 2.1004199617477994e+20
Gr17_im_1_1 0 s1 x17_im_a1 0 4.0233483542165737e+20
Gr18_1_1 0 s1 x18_a1 0 -4.164999233870067e+19
Gr19_1_1 0 s1 x19_a1 0 2.044465104964163e+21
Gr20_1_1 0 s1 x20_a1 0 -9.687517039186957e+20
Gr21_re_1_1 0 s1 x21_re_a1 0 -2.070168989472342e+20
Gr21_im_1_1 0 s1 x21_im_a1 0 1.0910457484197587e+21
Gr22_1_1 0 s1 x22_a1 0 1.2908007171858437e+20
Gd1_2 0 s1 p2 0 4.578200139630556
Fd1_2 0 s1 V2 228.9100069815278
Gr1_1_2 0 s1 x1_a2 0 -3476624913418416.5
Gr2_re_1_2 0 s1 x2_re_a2 0 -16016007948460.09
Gr2_im_1_2 0 s1 x2_im_a2 0 -247026016450878.62
Gr3_re_1_2 0 s1 x3_re_a2 0 243635565299499.75
Gr3_im_1_2 0 s1 x3_im_a2 0 -23645062079914.133
Gr4_re_1_2 0 s1 x4_re_a2 0 -1.4667467567447302e+17
Gr4_im_1_2 0 s1 x4_im_a2 0 -2.8206915795126844e+16
Gr5_re_1_2 0 s1 x5_re_a2 0 4.466969110459755e+17
Gr5_im_1_2 0 s1 x5_im_a2 0 -1.571701879490789e+17
Gr6_re_1_2 0 s1 x6_re_a2 0 -3.4682125583827524e+16
Gr6_im_1_2 0 s1 x6_im_a2 0 1.7594929165196606e+16
Gr7_1_2 0 s1 x7_a2 0 -1.5489565696968836e+22
Gr8_re_1_2 0 s1 x8_re_a2 0 -2.346633616015047e+19
Gr8_im_1_2 0 s1 x8_im_a2 0 8.141252541644558e+18
Gr9_1_2 0 s1 x9_a2 0 2.5099771369135806e+21
Gr10_1_2 0 s1 x10_a2 0 -4.3673969970078826e+21
Gr11_1_2 0 s1 x11_a2 0 1.5476757542337685e+22
Gr12_1_2 0 s1 x12_a2 0 -1.9064979707889404e+21
Gr13_1_2 0 s1 x13_a2 0 -4.817566009481393e+21
Gr14_1_2 0 s1 x14_a2 0 6.324004948196344e+21
Gr15_1_2 0 s1 x15_a2 0 5.063236483814719e+20
Gr16_1_2 0 s1 x16_a2 0 8.813785445320115e+20
Gr17_re_1_2 0 s1 x17_re_a2 0 1.6687626009146104e+20
Gr17_im_1_2 0 s1 x17_im_a2 0 3.196438502713868e+20
Gr18_1_2 0 s1 x18_a2 0 -3.2988396824597254e+19
Gr19_1_2 0 s1 x19_a2 0 1.6243310834818713e+21
Gr20_1_2 0 s1 x20_a2 0 -7.697113484561881e+20
Gr21_re_1_2 0 s1 x21_re_a2 0 -1.6446855132636443e+20
Gr21_im_1_2 0 s1 x21_im_a2 0 8.668091366845134e+20
Gr22_1_2 0 s1 x22_a2 0 1.0254310143704033e+20
*
* State networks driven by port 1
Cx1_a1 x1_a1 0 1.0
Gx1_a1 0 x1_a1 p1 0 0.07071067811865475
Fx1_a1 0 x1_a1 V1 3.5355339059327378
Rp1_a1 0 x1_a1 2.8140351223115325e-11
Cx2_re_a1 x2_re_a1 0 1.0
Gx2_re_a1 0 x2_re_a1 p1 0 0.1414213562373095
Fx2_re_a1 0 x2_re_a1 V1 7.0710678118654755
Rp2_re_re_a1 0 x2_re_a1 1.3002076588807512e-10
Gp2_re_im_a1 0 x2_re_a1 x2_im_a1 0 18939039599.22528
Cx2_im_a1 x2_im_a1 0 1.0
Gp2_im_re_a1 0 x2_im_a1 x2_re_a1 0 -18939039599.22528
Rp2_im_im_a1 0 x2_im_a1 1.3002076588807512e-10
Cx3_re_a1 x3_re_a1 0 1.0
Gx3_re_a1 0 x3_re_a1 p1 0 0.1414213562373095
Fx3_re_a1 0 x3_re_a1 V1 7.0710678118654755
Rp3_re_re_a1 0 x3_re_a1 1.961538750256935e-10
Gp3_re_im_a1 0 x3_re_a1 x3_im_a1 0 15054962753.362295
Cx3_im_a1 x3_im_a1 0 1.0
Gp3_im_re_a1 0 x3_im_a1 x3_re_a1 0 -15054962753.362295
Rp3_im_im_a1 0 x3_im_a1 1.961538750256935e-10
Cx4_re_a1 x4_re_a1 0 1.0
Gx4_re_a1 0 x4_re_a1 p1 0 0.1414213562373095
Fx4_re_a1 0 x4_re_a1 V1 7.0710678118654755
Rp4_re_re_a1 0 x4_re_a1 1.0934421701962196e-10
Gp4_re_im_a1 0 x4_re_a1 x4_im_a1 0 10860612252.810225
Cx4_im_a1 x4_im_a1 0 1.0
Gp4_im_re_a1 0 x4_im_a1 x4_re_a1 0 -10860612252.810225
Rp4_im_im_a1 0 x4_im_a1 1.0934421701962196e-10
Cx5_re_a1 x5_re_a1 0 1.0
Gx5_re_a1 0 x5_re_a1 p1 0 0.1414213562373095
Fx5_re_a1 0 x5_re_a1 V1 7.0710678118654755
Rp5_re_re_a1 0 x5_re_a1 9.754553423623866e-11
Gp5_re_im_a1 0 x5_re_a1 x5_im_a1 0 8767438004.13551
Cx5_im_a1 x5_im_a1 0 1.0
Gp5_im_re_a1 0 x5_im_a1 x5_re_a1 0 -8767438004.13551
Rp5_im_im_a1 0 x5_im_a1 9.754553423623866e-11
Cx6_re_a1 x6_re_a1 0 1.0
Gx6_re_a1 0 x6_re_a1 p1 0 0.1414213562373095
Fx6_re_a1 0 x6_re_a1 V1 7.0710678118654755
Rp6_re_re_a1 0 x6_re_a1 1.475741650643225e-10
Gp6_re_im_a1 0 x6_re_a1 x6_im_a1 0 9857624624.01335
Cx6_im_a1 x6_im_a1 0 1.0
Gp6_im_re_a1 0 x6_im_a1 x6_re_a1 0 -9857624624.01335
Rp6_im_im_a1 0 x6_im_a1 1.475741650643225e-10
Cx7_a1 x7_a1 0 1.0
Gx7_a1 0 x7_a1 p1 0 0.07071067811865475
Fx7_a1 0 x7_a1 V1 3.5355339059327378
Rp7_a1 0 x7_a1 1.669789241062161e-10
Cx8_re_a1 x8_re_a1 0 1.0
Gx8_re_a1 0 x8_re_a1 p1 0 0.1414213562373095
Fx8_re_a1 0 x8_re_a1 V1 7.0710678118654755
Rp8_re_re_a1 0 x8_re_a1 1.1803520003510855e-10
Gp8_re_im_a1 0 x8_re_a1 x8_im_a1 0 1522642821.9576526
Cx8_im_a1 x8_im_a1 0 1.0
Gp8_im_re_a1 0 x8_im_a1 x8_re_a1 0 -1522642821.9576526
Rp8_im_im_a1 0 x8_im_a1 1.1803520003510855e-10
Cx9_a1 x9_a1 0 1.0
Gx9_a1 0 x9_a1 p1 0 0.07071067811865475
Fx9_a1 0 x9_a1 V1 3.5355339059327378
Rp9_a1 0 x9_a1 2.742562251295646e-10
Cx10_a1 x10_a1 0 1.0
Gx10_a1 0 x10_a1 p1 0 0.07071067811865475
Fx10_a1 0 x10_a1 V1 3.5355339059327378
Rp10_a1 0 x10_a1 2.940702956412914e-10
Cx11_a1 x11_a1 0 1.0
Gx11_a1 0 x11_a1 p1 0 0.07071067811865475
Fx11_a1 0 x11_a1 V1 3.5355339059327378
Rp11_a1 0 x11_a1 1.6665155503996398e-10
Cx12_a1 x12_a1 0 1.0
Gx12_a1 0 x12_a1 p1 0 0.07071067811865475
Fx12_a1 0 x12_a1 V1 3.5355339059327378
Rp12_a1 0 x12_a1 5.52676771501589e-10
Cx13_a1 x13_a1 0 1.0
Gx13_a1 0 x13_a1 p1 0 0.07071067811865475
Fx13_a1 0 x13_a1 V1 3.5355339059327378
Rp13_a1 0 x13_a1 2.7028107521008506e-10
Cx14_a1 x14_a1 0 1.0
Gx14_a1 0 x14_a1 p1 0 0.07071067811865475
Fx14_a1 0 x14_a1 V1 3.5355339059327378
Rp14_a1 0 x14_a1 2.792419414391015e-10
Cx15_a1 x15_a1 0 1.0
Gx15_a1 0 x15_a1 p1 0 0.07071067811865475
Fx15_a1 0 x15_a1 V1 3.5355339059327378
Rp15_a1 0 x15_a1 9.344878341142427e-10
Cx16_a1 x16_a1 0 1.0
Gx16_a1 0 x16_a1 p1 0 0.07071067811865475
Fx16_a1 0 x16_a1 V1 3.5355339059327378
Rp16_a1 0 x16_a1 4.1002959044691536e-10
Cx17_re_a1 x17_re_a1 0 1.0
Gx17_re_a1 0 x17_re_a1 p1 0 0.1414213562373095
Fx17_re_a1 0 x17_re_a1 V1 7.0710678118654755
Rp17_re_re_a1 0 x17_re_a1 2.6951541025274634e-09
Gp17_re_im_a1 0 x17_re_a1 x17_im_a1 0 28862445.417143136
Cx17_im_a1 x17_im_a1 0 1.0
Gp17_im_re_a1 0 x17_im_a1 x17_re_a1 0 -28862445.417143136
Rp17_im_im_a1 0 x17_im_a1 2.6951541025274634e-09
Cx18_a1 x18_a1 0 1.0
Gx18_a1 0 x18_a1 p1 0 0.07071067811865475
Fx18_a1 0 x18_a1 V1 3.5355339059327378
Rp18_a1 0 x18_a1 5.263950320673343e-10
Cx19_a1 x19_a1 0 1.0
Gx19_a1 0 x19_a1 p1 0 0.07071067811865475
Fx19_a1 0 x19_a1 V1 3.5355339059327378
Rp19_a1 0 x19_a1 6.036735703708457e-10
Cx20_a1 x20_a1 0 1.0
Gx20_a1 0 x20_a1 p1 0 0.07071067811865475
Fx20_a1 0 x20_a1 V1 3.5355339059327378
Rp20_a1 0 x20_a1 9.467500886507113e-10
Cx21_re_a1 x21_re_a1 0 1.0
Gx21_re_a1 0 x21_re_a1 p1 0 0.1414213562373095
Fx21_re_a1 0 x21_re_a1 V1 7.0710678118654755
Rp21_re_re_a1 0 x21_re_a1 1.920523974103273e-09
Gp21_re_im_a1 0 x21_re_a1 x21_im_a1 0 42956269.204057515
Cx21_im_a1 x21_im_a1 0 1.0
Gp21_im_re_a1 0 x21_im_a1 x21_re_a1 0 -42956269.204057515
Rp21_im_im_a1 0 x21_im_a1 1.920523974103273e-09
Cx22_a1 x22_a1 0 1.0
Gx22_a1 0 x22_a1 p1 0 0.07071067811865475
Fx22_a1 0 x22_a1 V1 3.5355339059327378
Rp22_a1 0 x22_a1 2.6235290688152587e-09
*
* Port network for port 2
V2 p2 s2 0
R2 s2 0 50.0
Gd2_1 0 s2 p1 0 4.578200139630556
Fd2_1 0 s2 V1 228.9100069815278
Gr1_2_1 0 s2 x1_a1 0 -3476624994969503.5
Gr2_re_2_1 0 s2 x2_re_a1 0 -16015958966293.178
Gr2_im_2_1 0 s2 x2_im_a1 0 -247026014795638.4
Gr3_re_2_1 0 s2 x3_re_a1 0 243635587884976.2
Gr3_im_2_1 0 s2 x3_im_a1 0 -23645007279610.906
Gr4_re_2_1 0 s2 x4_re_a1 0 -1.466746869761597e+17
Gr4_im_2_1 0 s2 x4_im_a1 0 -2.820694069338716e+16
Gr5_re_2_1 0 s2 x5_re_a1 0 4.4669698414133274e+17
Gr5_im_2_1 0 s2 x5_im_a1 0 -1.5717015359505098e+17
Gr6_re_2_1 0 s2 x6_re_a1 0 -3.468213347459286e+16
Gr6_im_2_1 0 s2 x6_im_a1 0 1.7594925664863802e+16
Gr7_2_1 0 s2 x7_a1 0 -1.5489570375264467e+22
Gr8_re_2_1 0 s2 x8_re_a1 0 -2.3466341557294875e+19
Gr8_im_2_1 0 s2 x8_im_a1 0 8.141253481767178e+18
Gr9_2_1 0 s2 x9_a1 0 2.509977916394386e+21
Gr10_2_1 0 s2 x10_a1 0 -4.367398418220772e+21
Gr11_2_1 0 s2 x11_a1 0 1.5476762208391418e+22
Gr12_2_1 0 s2 x12_a1 0 -1.906498597199604e+21
Gr13_2_1 0 s2 x13_a1 0 -4.817567365019849e+21
Gr14_2_1 0 s2 x14_a1 0 6.324006809245162e+21
Gr15_2_1 0 s2 x15_a1 0 5.0632377938685585e+20
Gr16_2_1 0 s2 x16_a1 0 8.813789162604526e+20
Gr17_re_2_1 0 s2 x17_re_a1 0 1.668763393141976e+20
Gr17_im_2_1 0 s2 x17_im_a1 0 3.196440180225976e+20
Gr18_2_1 0 s2 x18_a1 0 -3.298858376964362e+19
Gr19_2_1 0 s2 x19_a1 0 1.6243317604856549e+21
Gr20_2_1 0 s2 x20_a1 0 -7.697116075835703e+20
Gr21_re_2_1 0 s2 x21_re_a1 0 -1.6446863926892842e+20
Gr21_im_2_1 0 s2 x21_im_a1 0 8.668095778376649e+20
Gr22_2_1 0 s2 x22_a1 0 1.0254317077222062e+20
Gd2_2 0 s2 p2 0 5.760538073218299
Fd2_2 0 s2 V2 288.02690366091497
Gr1_2_2 0 s2 x1_a2 0 -4374062912378871.5
Gr2_re_2_2 0 s2 x2_re_a2 0 -20172108641599.51
Gr2_im_2_2 0 s2 x2_im_a2 0 -310700610690676.44
Gr3_re_2_2 0 s2 x3_re_a2 0 306413815530138.94
Gr3_im_2_2 0 s2 x3_im_a2 0 -29684648923563.566
Gr4_re_2_2 0 s2 x4_re_a2 0 -1.8451269845540765e+17
Gr4_im_2_2 0 s2 x4_im_a2 0 -3.5506404364748464e+16
Gr5_re_2_2 0 s2 x5_re_a2 0 5.619943359140442e+17
Gr5_im_2_2 0 s2 x5_im_a2 0 -1.9767592687359414e+17
Gr6_re_2_2 0 s2 x6_re_a2 0 -4.363582070317699e+16
Gr6_im_2_2 0 s2 x6_im_a2 0 2.212631615377137e+16
Gr7_2_2 0 s2 x7_a2 0 -1.949093579760772e+22
Gr8_re_2_2 0 s2 x8_re_a2 0 -2.9526438321163866e+19
Gr8_im_2_2 0 s2 x8_im_a2 0 1.024260613593556e+19
Gr9_2_2 0 s2 x9_a2 0 3.158393380670566e+21
Gr10_2_2 0 s2 x10_a2 0 -5.495708333331713e+21
Gr11_2_2 0 s2 x11_a2 0 1.9474810161672395e+22
Gr12_2_2 0 s2 x12_a2 0 -2.3990386911181275e+21
Gr13_2_2 0 s2 x13_a2 0 -6.061987897234608e+21
Gr14_2_2 0 s2 x14_a2 0 7.957628967518975e+21
Gr15_2_2 0 s2 x15_a2 0 6.371074847354915e+20
Gr16_2_2 0 s2 x16_a2 0 1.1091479182541925e+21
Gr17_re_2_2 0 s2 x17_re_a2 0 2.100021336384159e+20
Gr17_im_2_2 0 s2 x17_im_a2 0 4.0225847920159215e+20
Gr18_2_2 0 s2 x18_a2 0 -4.1642081307262116e+19
Gr19_2_2 0 s2 x19_a2 0 2.0440770894460803e+21
Gr20_2_2 0 s2 x20_a2 0 -9.68567848371206e+20
Gr21_re_2_2 0 s2 x21_re_a2 0 -2.069776107852723e+20
Gr21_im_2_2 0 s2 x21_im_a2 0 1.0908386855419381e+21
Gr22_2_2 0 s2 x22_a2 0 1.2905557471554267e+20
*
* State networks driven by port 2
Cx1_a2 x1_a2 0 1.0
Gx1_a2 0 x1_a2 p2 0 0.07071067811865475
Fx1_a2 0 x1_a2 V2 3.5355339059327378
Rp1_a2 0 x1_a2 2.8140351223115325e-11
Cx2_re_a2 x2_re_a2 0 1.0
Gx2_re_a2 0 x2_re_a2 p2 0 0.1414213562373095
Fx2_re_a2 0 x2_re_a2 V2 7.0710678118654755
Rp2_re_re_a2 0 x2_re_a2 1.3002076588807512e-10
Gp2_re_im_a2 0 x2_re_a2 x2_im_a2 0 18939039599.22528
Cx2_im_a2 x2_im_a2 0 1.0
Gp2_im_re_a2 0 x2_im_a2 x2_re_a2 0 -18939039599.22528
Rp2_im_im_a2 0 x2_im_a2 1.3002076588807512e-10
Cx3_re_a2 x3_re_a2 0 1.0
Gx3_re_a2 0 x3_re_a2 p2 0 0.1414213562373095
Fx3_re_a2 0 x3_re_a2 V2 7.0710678118654755
Rp3_re_re_a2 0 x3_re_a2 1.961538750256935e-10
Gp3_re_im_a2 0 x3_re_a2 x3_im_a2 0 15054962753.362295
Cx3_im_a2 x3_im_a2 0 1.0
Gp3_im_re_a2 0 x3_im_a2 x3_re_a2 0 -15054962753.362295
Rp3_im_im_a2 0 x3_im_a2 1.961538750256935e-10
Cx4_re_a2 x4_re_a2 0 1.0
Gx4_re_a2 0 x4_re_a2 p2 0 0.1414213562373095
Fx4_re_a2 0 x4_re_a2 V2 7.0710678118654755
Rp4_re_re_a2 0 x4_re_a2 1.0934421701962196e-10
Gp4_re_im_a2 0 x4_re_a2 x4_im_a2 0 10860612252.810225
Cx4_im_a2 x4_im_a2 0 1.0
Gp4_im_re_a2 0 x4_im_a2 x4_re_a2 0 -10860612252.810225
Rp4_im_im_a2 0 x4_im_a2 1.0934421701962196e-10
Cx5_re_a2 x5_re_a2 0 1.0
Gx5_re_a2 0 x5_re_a2 p2 0 0.1414213562373095
Fx5_re_a2 0 x5_re_a2 V2 7.0710678118654755
Rp5_re_re_a2 0 x5_re_a2 9.754553423623866e-11
Gp5_re_im_a2 0 x5_re_a2 x5_im_a2 0 8767438004.13551
Cx5_im_a2 x5_im_a2 0 1.0
Gp5_im_re_a2 0 x5_im_a2 x5_re_a2 0 -8767438004.13551
Rp5_im_im_a2 0 x5_im_a2 9.754553423623866e-11
Cx6_re_a2 x6_re_a2 0 1.0
Gx6_re_a2 0 x6_re_a2 p2 0 0.1414213562373095
Fx6_re_a2 0 x6_re_a2 V2 7.0710678118654755
Rp6_re_re_a2 0 x6_re_a2 1.475741650643225e-10
Gp6_re_im_a2 0 x6_re_a2 x6_im_a2 0 9857624624.01335
Cx6_im_a2 x6_im_a2 0 1.0
Gp6_im_re_a2 0 x6_im_a2 x6_re_a2 0 -9857624624.01335
Rp6_im_im_a2 0 x6_im_a2 1.475741650643225e-10
Cx7_a2 x7_a2 0 1.0
Gx7_a2 0 x7_a2 p2 0 0.07071067811865475
Fx7_a2 0 x7_a2 V2 3.5355339059327378
Rp7_a2 0 x7_a2 1.669789241062161e-10
Cx8_re_a2 x8_re_a2 0 1.0
Gx8_re_a2 0 x8_re_a2 p2 0 0.1414213562373095
Fx8_re_a2 0 x8_re_a2 V2 7.0710678118654755
Rp8_re_re_a2 0 x8_re_a2 1.1803520003510855e-10
Gp8_re_im_a2 0 x8_re_a2 x8_im_a2 0 1522642821.9576526
Cx8_im_a2 x8_im_a2 0 1.0
Gp8_im_re_a2 0 x8_im_a2 x8_re_a2 0 -1522642821.9576526
Rp8_im_im_a2 0 x8_im_a2 1.1803520003510855e-10
Cx9_a2 x9_a2 0 1.0
Gx9_a2 0 x9_a2 p2 0 0.07071067811865475
Fx9_a2 0 x9_a2 V2 3.5355339059327378
Rp9_a2 0 x9_a2 2.742562251295646e-10
Cx10_a2 x10_a2 0 1.0
Gx10_a2 0 x10_a2 p2 0 0.07071067811865475
Fx10_a2 0 x10_a2 V2 3.5355339059327378
Rp10_a2 0 x10_a2 2.940702956412914e-10
Cx11_a2 x11_a2 0 1.0
Gx11_a2 0 x11_a2 p2 0 0.07071067811865475
Fx11_a2 0 x11_a2 V2 3.5355339059327378
Rp11_a2 0 x11_a2 1.6665155503996398e-10
Cx12_a2 x12_a2 0 1.0
Gx12_a2 0 x12_a2 p2 0 0.07071067811865475
Fx12_a2 0 x12_a2 V2 3.5355339059327378
Rp12_a2 0 x12_a2 5.52676771501589e-10
Cx13_a2 x13_a2 0 1.0
Gx13_a2 0 x13_a2 p2 0 0.07071067811865475
Fx13_a2 0 x13_a2 V2 3.5355339059327378
Rp13_a2 0 x13_a2 2.7028107521008506e-10
Cx14_a2 x14_a2 0 1.0
Gx14_a2 0 x14_a2 p2 0 0.07071067811865475
Fx14_a2 0 x14_a2 V2 3.5355339059327378
Rp14_a2 0 x14_a2 2.792419414391015e-10
Cx15_a2 x15_a2 0 1.0
Gx15_a2 0 x15_a2 p2 0 0.07071067811865475
Fx15_a2 0 x15_a2 V2 3.5355339059327378
Rp15_a2 0 x15_a2 9.344878341142427e-10
Cx16_a2 x16_a2 0 1.0
Gx16_a2 0 x16_a2 p2 0 0.07071067811865475
Fx16_a2 0 x16_a2 V2 3.5355339059327378
Rp16_a2 0 x16_a2 4.1002959044691536e-10
Cx17_re_a2 x17_re_a2 0 1.0
Gx17_re_a2 0 x17_re_a2 p2 0 0.1414213562373095
Fx17_re_a2 0 x17_re_a2 V2 7.0710678118654755
Rp17_re_re_a2 0 x17_re_a2 2.6951541025274634e-09
Gp17_re_im_a2 0 x17_re_a2 x17_im_a2 0 28862445.417143136
Cx17_im_a2 x17_im_a2 0 1.0
Gp17_im_re_a2 0 x17_im_a2 x17_re_a2 0 -28862445.417143136
Rp17_im_im_a2 0 x17_im_a2 2.6951541025274634e-09
Cx18_a2 x18_a2 0 1.0
Gx18_a2 0 x18_a2 p2 0 0.07071067811865475
Fx18_a2 0 x18_a2 V2 3.5355339059327378
Rp18_a2 0 x18_a2 5.263950320673343e-10
Cx19_a2 x19_a2 0 1.0
Gx19_a2 0 x19_a2 p2 0 0.07071067811865475
Fx19_a2 0 x19_a2 V2 3.5355339059327378
Rp19_a2 0 x19_a2 6.036735703708457e-10
Cx20_a2 x20_a2 0 1.0
Gx20_a2 0 x20_a2 p2 0 0.07071067811865475
Fx20_a2 0 x20_a2 V2 3.5355339059327378
Rp20_a2 0 x20_a2 9.467500886507113e-10
Cx21_re_a2 x21_re_a2 0 1.0
Gx21_re_a2 0 x21_re_a2 p2 0 0.1414213562373095
Fx21_re_a2 0 x21_re_a2 V2 7.0710678118654755
Rp21_re_re_a2 0 x21_re_a2 1.920523974103273e-09
Gp21_re_im_a2 0 x21_re_a2 x21_im_a2 0 42956269.204057515
Cx21_im_a2 x21_im_a2 0 1.0
Gp21_im_re_a2 0 x21_im_a2 x21_re_a2 0 -42956269.204057515
Rp21_im_im_a2 0 x21_im_a2 1.920523974103273e-09
Cx22_a2 x22_a2 0 1.0
Gx22_a2 0 x22_a2 p2 0 0.07071067811865475
Fx22_a2 0 x22_a2 V2 3.5355339059327378
Rp22_a2 0 x22_a2 2.6235290688152587e-09
.ENDS s_equivalent
