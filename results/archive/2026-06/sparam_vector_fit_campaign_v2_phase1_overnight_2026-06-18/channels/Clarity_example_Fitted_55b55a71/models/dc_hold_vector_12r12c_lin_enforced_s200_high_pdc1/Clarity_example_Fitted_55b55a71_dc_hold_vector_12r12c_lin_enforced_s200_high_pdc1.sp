* EQUIVALENT CIRCUIT FOR VECTOR FITTED S-MATRIX
* Created using scikit-rf vectorFitting.py
*
.SUBCKT s_equivalent p1 p2
*
* Port network for port 1
V1 p1 s1 0
R1 s1 0 50.0
Gd1_1 0 s1 p1 0 -0.00014010064965444658
Fd1_1 0 s1 V1 -0.007005032482722329
Gr1_1_1 0 s1 x1_a1 0 -3.030544352374722e+22
Gr2_1_1 0 s1 x2_a1 0 9.474113005392055e+17
Gr3_re_1_1 0 s1 x3_re_a1 0 -9620437646360.963
Gr3_im_1_1 0 s1 x3_im_a1 0 3120387662515.1904
Gr4_1_1 0 s1 x4_a1 0 34118270429.109524
Gr5_re_1_1 0 s1 x5_re_a1 0 -68228358208.242775
Gr5_im_1_1 0 s1 x5_im_a1 0 -15397248905.177345
Gr6_re_1_1 0 s1 x6_re_a1 0 35239636471485.65
Gr6_im_1_1 0 s1 x6_im_a1 0 361737530061.94855
Gr7_re_1_1 0 s1 x7_re_a1 0 2.6785076509101236e+16
Gr7_im_1_1 0 s1 x7_im_a1 0 2.7671990503015836e+16
Gr8_re_1_1 0 s1 x8_re_a1 0 7.133831988001192e+18
Gr8_im_1_1 0 s1 x8_im_a1 0 2.4129520536758267e+18
Gr9_1_1 0 s1 x9_a1 0 8.821580531728838e+19
Gr10_re_1_1 0 s1 x10_re_a1 0 7.330232802620384e+19
Gr10_im_1_1 0 s1 x10_im_a1 0 -1.276538260969767e+20
Gr11_re_1_1 0 s1 x11_re_a1 0 -4.7887343530888765e+19
Gr11_im_1_1 0 s1 x11_im_a1 0 -4.676879116432734e+19
Gr12_re_1_1 0 s1 x12_re_a1 0 -1.3741707792241792e+18
Gr12_im_1_1 0 s1 x12_im_a1 0 7.718743104301208e+19
Gr13_re_1_1 0 s1 x13_re_a1 0 -5.79835016272371e+19
Gr13_im_1_1 0 s1 x13_im_a1 0 1.7577845100519074e+19
Gr14_re_1_1 0 s1 x14_re_a1 0 -2.428369647158296e+19
Gr14_im_1_1 0 s1 x14_im_a1 0 -7.493299622926183e+18
Gr15_re_1_1 0 s1 x15_re_a1 0 -2.3574821199873075e+18
Gr15_im_1_1 0 s1 x15_im_a1 0 -5.860269219085873e+19
Gr16_1_1 0 s1 x16_a1 0 3.526529544371334e+18
Gr17_1_1 0 s1 x17_a1 0 5.455512674622738e+18
Gr18_1_1 0 s1 x18_a1 0 3.8389760287879373e+18
Gr19_1_1 0 s1 x19_a1 0 3.1789906059892526e+18
Gr20_1_1 0 s1 x20_a1 0 1.4570217942959532e+18
Gr21_1_1 0 s1 x21_a1 0 5.7171085578470246e+17
Gr22_1_1 0 s1 x22_a1 0 3.835759880650107e+17
Gr23_1_1 0 s1 x23_a1 0 2.1830574899361267e+17
Gr24_1_1 0 s1 x24_a1 0 6.540589996128331e-07
Gr25_1_1 0 s1 x25_a1 0 1.2707767475914281e-09
Gd1_2 0 s1 p2 0 -2.5162356253249917e-05
Fd1_2 0 s1 V2 -0.001258117812662496
Gr1_1_2 0 s1 x1_a2 0 -3.1892418632602136e+22
Gr2_1_2 0 s1 x2_a2 0 9.95654779471322e+17
Gr3_re_1_2 0 s1 x3_re_a2 0 -11677076872036.773
Gr3_im_1_2 0 s1 x3_im_a2 0 5381468729614.913
Gr4_1_2 0 s1 x4_a2 0 -80874099739.29614
Gr5_re_1_2 0 s1 x5_re_a2 0 -58409116884.96984
Gr5_im_1_2 0 s1 x5_im_a2 0 -38776001891.02897
Gr6_re_1_2 0 s1 x6_re_a2 0 33655686163152.32
Gr6_im_1_2 0 s1 x6_im_a2 0 292068509294.0754
Gr7_re_1_2 0 s1 x7_re_a2 0 2.5301534791426092e+16
Gr7_im_1_2 0 s1 x7_im_a2 0 2.569430621061223e+16
Gr8_re_1_2 0 s1 x8_re_a2 0 6.641072757055269e+18
Gr8_im_1_2 0 s1 x8_im_a2 0 2.2051576201942436e+18
Gr9_1_2 0 s1 x9_a2 0 8.19179360847817e+19
Gr10_re_1_2 0 s1 x10_re_a2 0 6.749040963285122e+19
Gr10_im_1_2 0 s1 x10_im_a2 0 -1.1837737233375864e+20
Gr11_re_1_2 0 s1 x11_re_a2 0 -4.4383466183344955e+19
Gr11_im_1_2 0 s1 x11_im_a2 0 -4.300027545893402e+19
Gr12_re_1_2 0 s1 x12_re_a2 0 -1.0811552499275963e+18
Gr12_im_1_2 0 s1 x12_im_a2 0 7.123605719727708e+19
Gr13_re_1_2 0 s1 x13_re_a2 0 -5.353526813817171e+19
Gr13_im_1_2 0 s1 x13_im_a2 0 1.625703567182464e+19
Gr14_re_1_2 0 s1 x14_re_a2 0 -2.246226819463976e+19
Gr14_im_1_2 0 s1 x14_im_a2 0 -6.872542040773205e+18
Gr15_re_1_2 0 s1 x15_re_a2 0 -2.2069030873196508e+18
Gr15_im_1_2 0 s1 x15_im_a2 0 -5.397286763174544e+19
Gr16_1_2 0 s1 x16_a2 0 3.215111122270291e+18
Gr17_1_2 0 s1 x17_a2 0 5.00960525225421e+18
Gr18_1_2 0 s1 x18_a2 0 3.532925526174847e+18
Gr19_1_2 0 s1 x19_a2 0 2.926202627957529e+18
Gr20_1_2 0 s1 x20_a2 0 1.3417291783121705e+18
Gr21_1_2 0 s1 x21_a2 0 5.2657576605942496e+17
Gr22_1_2 0 s1 x22_a2 0 3.533106104624949e+17
Gr23_1_2 0 s1 x23_a2 0 2.010905044422015e+17
Gr24_1_2 0 s1 x24_a2 0 2.487990579730895e-07
Gr25_1_2 0 s1 x25_a2 0 4.833945677582204e-10
*
* State networks driven by port 1
Cx1_a1 x1_a1 0 1.0
Gx1_a1 0 x1_a1 p1 0 0.07071067811865475
Fx1_a1 0 x1_a1 V1 3.5355339059327378
Rp1_a1 0 x1_a1 2.950698768976813e-21
Cx2_a1 x2_a1 0 1.0
Gx2_a1 0 x2_a1 p1 0 0.07071067811865475
Fx2_a1 0 x2_a1 V1 3.5355339059327378
Rp2_a1 0 x2_a1 9.511316061120601e-17
Cx3_re_a1 x3_re_a1 0 1.0
Gx3_re_a1 0 x3_re_a1 p1 0 0.1414213562373095
Fx3_re_a1 0 x3_re_a1 V1 7.0710678118654755
Rp3_re_re_a1 0 x3_re_a1 2.997049269702367e-14
Gp3_re_im_a1 0 x3_re_a1 x3_im_a1 0 28110964462283.24
Cx3_im_a1 x3_im_a1 0 1.0
Gp3_im_re_a1 0 x3_im_a1 x3_re_a1 0 -28110964462283.24
Rp3_im_im_a1 0 x3_im_a1 2.997049269702367e-14
Cx4_a1 x4_a1 0 1.0
Gx4_a1 0 x4_a1 p1 0 0.07071067811865475
Fx4_a1 0 x4_a1 V1 3.5355339059327378
Rp4_a1 0 x4_a1 3.3258243424852374e-13
Cx5_re_a1 x5_re_a1 0 1.0
Gx5_re_a1 0 x5_re_a1 p1 0 0.1414213562373095
Fx5_re_a1 0 x5_re_a1 V1 7.0710678118654755
Rp5_re_re_a1 0 x5_re_a1 1.7053078481209685e-12
Gp5_re_im_a1 0 x5_re_a1 x5_im_a1 0 476180502936.4674
Cx5_im_a1 x5_im_a1 0 1.0
Gp5_im_re_a1 0 x5_im_a1 x5_re_a1 0 -476180502936.4674
Rp5_im_im_a1 0 x5_im_a1 1.7053078481209685e-12
Cx6_re_a1 x6_re_a1 0 1.0
Gx6_re_a1 0 x6_re_a1 p1 0 0.1414213562373095
Fx6_re_a1 0 x6_re_a1 V1 7.0710678118654755
Rp6_re_re_a1 0 x6_re_a1 6.371960576607461e-12
Gp6_re_im_a1 0 x6_re_a1 x6_im_a1 0 127420678237.1624
Cx6_im_a1 x6_im_a1 0 1.0
Gp6_im_re_a1 0 x6_im_a1 x6_re_a1 0 -127420678237.1624
Rp6_im_im_a1 0 x6_im_a1 6.371960576607461e-12
Cx7_re_a1 x7_re_a1 0 1.0
Gx7_re_a1 0 x7_re_a1 p1 0 0.1414213562373095
Fx7_re_a1 0 x7_re_a1 V1 7.0710678118654755
Rp7_re_re_a1 0 x7_re_a1 1.5663726017152246e-11
Gp7_re_im_a1 0 x7_re_a1 x7_im_a1 0 52223492210.100845
Cx7_im_a1 x7_im_a1 0 1.0
Gp7_im_re_a1 0 x7_im_a1 x7_re_a1 0 -52223492210.100845
Rp7_im_im_a1 0 x7_im_a1 1.5663726017152246e-11
Cx8_re_a1 x8_re_a1 0 1.0
Gx8_re_a1 0 x8_re_a1 p1 0 0.1414213562373095
Fx8_re_a1 0 x8_re_a1 V1 7.0710678118654755
Rp8_re_re_a1 0 x8_re_a1 3.181959639543911e-11
Gp8_re_im_a1 0 x8_re_a1 x8_im_a1 0 27026136675.162857
Cx8_im_a1 x8_im_a1 0 1.0
Gp8_im_re_a1 0 x8_im_a1 x8_re_a1 0 -27026136675.162857
Rp8_im_im_a1 0 x8_im_a1 3.181959639543911e-11
Cx9_a1 x9_a1 0 1.0
Gx9_a1 0 x9_a1 p1 0 0.07071067811865475
Fx9_a1 0 x9_a1 V1 3.5355339059327378
Rp9_a1 0 x9_a1 3.370380569648424e-11
Cx10_re_a1 x10_re_a1 0 1.0
Gx10_re_a1 0 x10_re_a1 p1 0 0.1414213562373095
Fx10_re_a1 0 x10_re_a1 V1 7.0710678118654755
Rp10_re_re_a1 0 x10_re_a1 6.378091718953072e-11
Gp10_re_im_a1 0 x10_re_a1 x10_im_a1 0 15676927534.333195
Cx10_im_a1 x10_im_a1 0 1.0
Gp10_im_re_a1 0 x10_im_a1 x10_re_a1 0 -15676927534.333195
Rp10_im_im_a1 0 x10_im_a1 6.378091718953072e-11
Cx11_re_a1 x11_re_a1 0 1.0
Gx11_re_a1 0 x11_re_a1 p1 0 0.1414213562373095
Fx11_re_a1 0 x11_re_a1 V1 7.0710678118654755
Rp11_re_re_a1 0 x11_re_a1 1.5798323069020364e-10
Gp11_re_im_a1 0 x11_re_a1 x11_im_a1 0 18767495596.301014
Cx11_im_a1 x11_im_a1 0 1.0
Gp11_im_re_a1 0 x11_im_a1 x11_re_a1 0 -18767495596.301014
Rp11_im_im_a1 0 x11_im_a1 1.5798323069020364e-10
Cx12_re_a1 x12_re_a1 0 1.0
Gx12_re_a1 0 x12_re_a1 p1 0 0.1414213562373095
Fx12_re_a1 0 x12_re_a1 V1 7.0710678118654755
Rp12_re_re_a1 0 x12_re_a1 1.7986253513389033e-10
Gp12_re_im_a1 0 x12_re_a1 x12_im_a1 0 13980100100.327803
Cx12_im_a1 x12_im_a1 0 1.0
Gp12_im_re_a1 0 x12_im_a1 x12_re_a1 0 -13980100100.327803
Rp12_im_im_a1 0 x12_im_a1 1.7986253513389033e-10
Cx13_re_a1 x13_re_a1 0 1.0
Gx13_re_a1 0 x13_re_a1 p1 0 0.1414213562373095
Fx13_re_a1 0 x13_re_a1 V1 7.0710678118654755
Rp13_re_re_a1 0 x13_re_a1 1.287364715186983e-10
Gp13_re_im_a1 0 x13_re_a1 x13_im_a1 0 10094485057.897255
Cx13_im_a1 x13_im_a1 0 1.0
Gp13_im_re_a1 0 x13_im_a1 x13_re_a1 0 -10094485057.897255
Rp13_im_im_a1 0 x13_im_a1 1.287364715186983e-10
Cx14_re_a1 x14_re_a1 0 1.0
Gx14_re_a1 0 x14_re_a1 p1 0 0.1414213562373095
Fx14_re_a1 0 x14_re_a1 V1 7.0710678118654755
Rp14_re_re_a1 0 x14_re_a1 1.0606507645445938e-10
Gp14_re_im_a1 0 x14_re_a1 x14_im_a1 0 7055499164.933268
Cx14_im_a1 x14_im_a1 0 1.0
Gp14_im_re_a1 0 x14_im_a1 x14_re_a1 0 -7055499164.933268
Rp14_im_im_a1 0 x14_im_a1 1.0606507645445938e-10
Cx15_re_a1 x15_re_a1 0 1.0
Gx15_re_a1 0 x15_re_a1 p1 0 0.1414213562373095
Fx15_re_a1 0 x15_re_a1 V1 7.0710678118654755
Rp15_re_re_a1 0 x15_re_a1 1.2831897645969387e-10
Gp15_re_im_a1 0 x15_re_a1 x15_im_a1 0 1637376924.4051015
Cx15_im_a1 x15_im_a1 0 1.0
Gp15_im_re_a1 0 x15_im_a1 x15_re_a1 0 -1637376924.4051015
Rp15_im_im_a1 0 x15_im_a1 1.2831897645969387e-10
Cx16_a1 x16_a1 0 1.0
Gx16_a1 0 x16_a1 p1 0 0.07071067811865475
Fx16_a1 0 x16_a1 V1 3.5355339059327378
Rp16_a1 0 x16_a1 1.7778623385046862e-10
Cx17_a1 x17_a1 0 1.0
Gx17_a1 0 x17_a1 p1 0 0.07071067811865475
Fx17_a1 0 x17_a1 V1 3.5355339059327378
Rp17_a1 0 x17_a1 2.485395232504578e-10
Cx18_a1 x18_a1 0 1.0
Gx18_a1 0 x18_a1 p1 0 0.07071067811865475
Fx18_a1 0 x18_a1 V1 3.5355339059327378
Rp18_a1 0 x18_a1 4.548405682328741e-10
Cx19_a1 x19_a1 0 1.0
Gx19_a1 0 x19_a1 p1 0 0.07071067811865475
Fx19_a1 0 x19_a1 V1 3.5355339059327378
Rp19_a1 0 x19_a1 5.348783706572236e-10
Cx20_a1 x20_a1 0 1.0
Gx20_a1 0 x20_a1 p1 0 0.07071067811865475
Fx20_a1 0 x20_a1 V1 3.5355339059327378
Rp20_a1 0 x20_a1 9.219633096808902e-10
Cx21_a1 x21_a1 0 1.0
Gx21_a1 0 x21_a1 p1 0 0.07071067811865475
Fx21_a1 0 x21_a1 V1 3.5355339059327378
Rp21_a1 0 x21_a1 1.6052978415600169e-09
Cx22_a1 x22_a1 0 1.0
Gx22_a1 0 x22_a1 p1 0 0.07071067811865475
Fx22_a1 0 x22_a1 V1 3.5355339059327378
Rp22_a1 0 x22_a1 2.0052869989942374e-09
Cx23_a1 x23_a1 0 1.0
Gx23_a1 0 x23_a1 p1 0 0.07071067811865475
Fx23_a1 0 x23_a1 V1 3.5355339059327378
Rp23_a1 0 x23_a1 2.722824336602712e-09
Cx24_a1 x24_a1 0 1.0
Gx24_a1 0 x24_a1 p1 0 0.07071067811865475
Fx24_a1 0 x24_a1 V1 3.5355339059327378
Rp24_a1 0 x24_a1 3453.7657697020504
Cx25_a1 x25_a1 0 1.0
Gx25_a1 0 x25_a1 p1 0 0.07071067811865475
Fx25_a1 0 x25_a1 V1 3.5355339059327378
Rp25_a1 0 x25_a1 78355.04403096001
*
* Port network for port 2
V2 p2 s2 0
R2 s2 0 50.0
Gd2_1 0 s2 p1 0 -2.5162356253249917e-05
Fd2_1 0 s2 V1 -0.001258117812662496
Gr1_2_1 0 s2 x1_a1 0 -3.1892429299201037e+22
Gr2_2_1 0 s2 x2_a1 0 9.956551128079715e+17
Gr3_re_2_1 0 s2 x3_re_a1 0 -11677082257152.318
Gr3_im_2_1 0 s2 x3_im_a1 0 5381470071424.144
Gr4_2_1 0 s2 x4_a1 0 -80874172384.6865
Gr5_re_2_1 0 s2 x5_re_a1 0 -58409349882.86987
Gr5_im_2_1 0 s2 x5_im_a1 0 -38776052126.703575
Gr6_re_2_1 0 s2 x6_re_a1 0 33655755863897.332
Gr6_im_2_1 0 s2 x6_im_a1 0 292057132857.53284
Gr7_re_2_1 0 s2 x7_re_a1 0 2.5301582969618664e+16
Gr7_im_2_1 0 s2 x7_im_a1 0 2.5694345581446572e+16
Gr8_re_2_1 0 s2 x8_re_a1 0 6.641083536067285e+18
Gr8_im_2_1 0 s2 x8_im_a1 0 2.205160477331589e+18
Gr9_2_1 0 s2 x9_a1 0 8.191806607300546e+19
Gr10_re_2_1 0 s2 x10_re_a1 0 6.74905071209033e+19
Gr10_im_2_1 0 s2 x10_im_a1 0 -1.1837755705477344e+20
Gr11_re_2_1 0 s2 x11_re_a1 0 -4.4383534891131355e+19
Gr11_im_2_1 0 s2 x11_im_a1 0 -4.300033675315762e+19
Gr12_re_2_1 0 s2 x12_re_a1 0 -1.0811540566671692e+18
Gr12_im_2_1 0 s2 x12_im_a1 0 7.123616294795646e+19
Gr13_re_2_1 0 s2 x13_re_a1 0 -5.353534801401827e+19
Gr13_im_2_1 0 s2 x13_im_a1 0 1.6257060329862201e+19
Gr14_re_2_1 0 s2 x14_re_a1 0 -2.246230235975312e+19
Gr14_im_2_1 0 s2 x14_im_a1 0 -6.872551589515828e+18
Gr15_re_2_1 0 s2 x15_re_a1 0 -2.206906855043989e+18
Gr15_im_2_1 0 s2 x15_im_a1 0 -5.397294604631936e+19
Gr16_2_1 0 s2 x16_a1 0 3.2151152762573916e+18
Gr17_2_1 0 s2 x17_a1 0 5.009612294798714e+18
Gr18_2_1 0 s2 x18_a1 0 3.532930614630549e+18
Gr19_2_1 0 s2 x19_a1 0 2.9262068527215923e+18
Gr20_2_1 0 s2 x20_a1 0 1.3417311243660792e+18
Gr21_2_1 0 s2 x21_a1 0 5.265765314363175e+17
Gr22_2_1 0 s2 x22_a1 0 3.533111242644637e+17
Gr23_2_1 0 s2 x23_a1 0 2.0109079703132483e+17
Gr24_2_1 0 s2 x24_a1 0 2.4879926591707493e-07
Gr25_2_1 0 s2 x25_a1 0 4.833949717758777e-10
Gd2_2 0 s2 p2 0 -0.00013938754063199887
Fd2_2 0 s2 V2 -0.006969377031599944
Gr1_2_2 0 s2 x1_a2 0 -3.0508062441802465e+22
Gr2_2_2 0 s2 x2_a2 0 9.537368210233312e+17
Gr3_re_2_2 0 s2 x3_re_a2 0 -9694749277850.715
Gr3_im_2_2 0 s2 x3_im_a2 0 3154669243239.6255
Gr4_2_2 0 s2 x4_a2 0 33618557278.86674
Gr5_re_2_2 0 s2 x5_re_a2 0 -68588033368.73514
Gr5_im_2_2 0 s2 x5_im_a2 0 -15645843860.411497
Gr6_re_2_2 0 s2 x6_re_a2 0 35444952102354.125
Gr6_im_2_2 0 s2 x6_im_a2 0 361910432188.31964
Gr7_re_2_2 0 s2 x7_re_a2 0 2.6938948552741224e+16
Gr7_im_2_2 0 s2 x7_im_a2 0 2.782768815301582e+16
Gr8_re_2_2 0 s2 x8_re_a2 0 7.17413432237322e+18
Gr8_im_2_2 0 s2 x8_im_a2 0 2.4263136563364454e+18
Gr9_2_2 0 s2 x9_a2 0 8.871294945389306e+19
Gr10_re_2_2 0 s2 x10_re_a2 0 7.371173702809078e+19
Gr10_im_2_2 0 s2 x10_im_a2 0 -1.2837210473282226e+20
Gr11_re_2_2 0 s2 x11_re_a2 0 -4.815661068911336e+19
Gr11_im_2_2 0 s2 x11_im_a2 0 -4.702965783158477e+19
Gr12_re_2_2 0 s2 x12_re_a2 0 -1.380737885109909e+18
Gr12_im_2_2 0 s2 x12_im_a2 0 7.761962004189884e+19
Gr13_re_2_2 0 s2 x13_re_a2 0 -5.8308312411032895e+19
Gr13_im_2_2 0 s2 x13_im_a2 0 1.767647669320454e+19
Gr14_re_2_2 0 s2 x14_re_a2 0 -2.4419984634746454e+19
Gr14_im_2_2 0 s2 x14_im_a2 0 -7.534995108696308e+18
Gr15_re_2_2 0 s2 x15_re_a2 0 -2.370875160078742e+18
Gr15_im_2_2 0 s2 x15_im_a2 0 -5.893014158504882e+19
Gr16_2_2 0 s2 x16_a2 0 3.546031633968039e+18
Gr17_2_2 0 s2 x17_a2 0 5.48590370752074e+18
Gr18_2_2 0 s2 x18_a2 0 3.860409524904178e+18
Gr19_2_2 0 s2 x19_a2 0 3.1967433111874207e+18
Gr20_2_2 0 s2 x20_a2 0 1.4651618622559542e+18
Gr21_2_2 0 s2 x21_a2 0 5.749055214276598e+17
Gr22_2_2 0 s2 x22_a2 0 3.857194785193615e+17
Gr23_2_2 0 s2 x23_a2 0 2.1952574040077328e+17
Gr24_2_2 0 s2 x24_a2 0 6.520839651409417e-07
Gr25_2_2 0 s2 x25_a2 0 1.2669394488229927e-09
*
* State networks driven by port 2
Cx1_a2 x1_a2 0 1.0
Gx1_a2 0 x1_a2 p2 0 0.07071067811865475
Fx1_a2 0 x1_a2 V2 3.5355339059327378
Rp1_a2 0 x1_a2 2.950698768976813e-21
Cx2_a2 x2_a2 0 1.0
Gx2_a2 0 x2_a2 p2 0 0.07071067811865475
Fx2_a2 0 x2_a2 V2 3.5355339059327378
Rp2_a2 0 x2_a2 9.511316061120601e-17
Cx3_re_a2 x3_re_a2 0 1.0
Gx3_re_a2 0 x3_re_a2 p2 0 0.1414213562373095
Fx3_re_a2 0 x3_re_a2 V2 7.0710678118654755
Rp3_re_re_a2 0 x3_re_a2 2.997049269702367e-14
Gp3_re_im_a2 0 x3_re_a2 x3_im_a2 0 28110964462283.24
Cx3_im_a2 x3_im_a2 0 1.0
Gp3_im_re_a2 0 x3_im_a2 x3_re_a2 0 -28110964462283.24
Rp3_im_im_a2 0 x3_im_a2 2.997049269702367e-14
Cx4_a2 x4_a2 0 1.0
Gx4_a2 0 x4_a2 p2 0 0.07071067811865475
Fx4_a2 0 x4_a2 V2 3.5355339059327378
Rp4_a2 0 x4_a2 3.3258243424852374e-13
Cx5_re_a2 x5_re_a2 0 1.0
Gx5_re_a2 0 x5_re_a2 p2 0 0.1414213562373095
Fx5_re_a2 0 x5_re_a2 V2 7.0710678118654755
Rp5_re_re_a2 0 x5_re_a2 1.7053078481209685e-12
Gp5_re_im_a2 0 x5_re_a2 x5_im_a2 0 476180502936.4674
Cx5_im_a2 x5_im_a2 0 1.0
Gp5_im_re_a2 0 x5_im_a2 x5_re_a2 0 -476180502936.4674
Rp5_im_im_a2 0 x5_im_a2 1.7053078481209685e-12
Cx6_re_a2 x6_re_a2 0 1.0
Gx6_re_a2 0 x6_re_a2 p2 0 0.1414213562373095
Fx6_re_a2 0 x6_re_a2 V2 7.0710678118654755
Rp6_re_re_a2 0 x6_re_a2 6.371960576607461e-12
Gp6_re_im_a2 0 x6_re_a2 x6_im_a2 0 127420678237.1624
Cx6_im_a2 x6_im_a2 0 1.0
Gp6_im_re_a2 0 x6_im_a2 x6_re_a2 0 -127420678237.1624
Rp6_im_im_a2 0 x6_im_a2 6.371960576607461e-12
Cx7_re_a2 x7_re_a2 0 1.0
Gx7_re_a2 0 x7_re_a2 p2 0 0.1414213562373095
Fx7_re_a2 0 x7_re_a2 V2 7.0710678118654755
Rp7_re_re_a2 0 x7_re_a2 1.5663726017152246e-11
Gp7_re_im_a2 0 x7_re_a2 x7_im_a2 0 52223492210.100845
Cx7_im_a2 x7_im_a2 0 1.0
Gp7_im_re_a2 0 x7_im_a2 x7_re_a2 0 -52223492210.100845
Rp7_im_im_a2 0 x7_im_a2 1.5663726017152246e-11
Cx8_re_a2 x8_re_a2 0 1.0
Gx8_re_a2 0 x8_re_a2 p2 0 0.1414213562373095
Fx8_re_a2 0 x8_re_a2 V2 7.0710678118654755
Rp8_re_re_a2 0 x8_re_a2 3.181959639543911e-11
Gp8_re_im_a2 0 x8_re_a2 x8_im_a2 0 27026136675.162857
Cx8_im_a2 x8_im_a2 0 1.0
Gp8_im_re_a2 0 x8_im_a2 x8_re_a2 0 -27026136675.162857
Rp8_im_im_a2 0 x8_im_a2 3.181959639543911e-11
Cx9_a2 x9_a2 0 1.0
Gx9_a2 0 x9_a2 p2 0 0.07071067811865475
Fx9_a2 0 x9_a2 V2 3.5355339059327378
Rp9_a2 0 x9_a2 3.370380569648424e-11
Cx10_re_a2 x10_re_a2 0 1.0
Gx10_re_a2 0 x10_re_a2 p2 0 0.1414213562373095
Fx10_re_a2 0 x10_re_a2 V2 7.0710678118654755
Rp10_re_re_a2 0 x10_re_a2 6.378091718953072e-11
Gp10_re_im_a2 0 x10_re_a2 x10_im_a2 0 15676927534.333195
Cx10_im_a2 x10_im_a2 0 1.0
Gp10_im_re_a2 0 x10_im_a2 x10_re_a2 0 -15676927534.333195
Rp10_im_im_a2 0 x10_im_a2 6.378091718953072e-11
Cx11_re_a2 x11_re_a2 0 1.0
Gx11_re_a2 0 x11_re_a2 p2 0 0.1414213562373095
Fx11_re_a2 0 x11_re_a2 V2 7.0710678118654755
Rp11_re_re_a2 0 x11_re_a2 1.5798323069020364e-10
Gp11_re_im_a2 0 x11_re_a2 x11_im_a2 0 18767495596.301014
Cx11_im_a2 x11_im_a2 0 1.0
Gp11_im_re_a2 0 x11_im_a2 x11_re_a2 0 -18767495596.301014
Rp11_im_im_a2 0 x11_im_a2 1.5798323069020364e-10
Cx12_re_a2 x12_re_a2 0 1.0
Gx12_re_a2 0 x12_re_a2 p2 0 0.1414213562373095
Fx12_re_a2 0 x12_re_a2 V2 7.0710678118654755
Rp12_re_re_a2 0 x12_re_a2 1.7986253513389033e-10
Gp12_re_im_a2 0 x12_re_a2 x12_im_a2 0 13980100100.327803
Cx12_im_a2 x12_im_a2 0 1.0
Gp12_im_re_a2 0 x12_im_a2 x12_re_a2 0 -13980100100.327803
Rp12_im_im_a2 0 x12_im_a2 1.7986253513389033e-10
Cx13_re_a2 x13_re_a2 0 1.0
Gx13_re_a2 0 x13_re_a2 p2 0 0.1414213562373095
Fx13_re_a2 0 x13_re_a2 V2 7.0710678118654755
Rp13_re_re_a2 0 x13_re_a2 1.287364715186983e-10
Gp13_re_im_a2 0 x13_re_a2 x13_im_a2 0 10094485057.897255
Cx13_im_a2 x13_im_a2 0 1.0
Gp13_im_re_a2 0 x13_im_a2 x13_re_a2 0 -10094485057.897255
Rp13_im_im_a2 0 x13_im_a2 1.287364715186983e-10
Cx14_re_a2 x14_re_a2 0 1.0
Gx14_re_a2 0 x14_re_a2 p2 0 0.1414213562373095
Fx14_re_a2 0 x14_re_a2 V2 7.0710678118654755
Rp14_re_re_a2 0 x14_re_a2 1.0606507645445938e-10
Gp14_re_im_a2 0 x14_re_a2 x14_im_a2 0 7055499164.933268
Cx14_im_a2 x14_im_a2 0 1.0
Gp14_im_re_a2 0 x14_im_a2 x14_re_a2 0 -7055499164.933268
Rp14_im_im_a2 0 x14_im_a2 1.0606507645445938e-10
Cx15_re_a2 x15_re_a2 0 1.0
Gx15_re_a2 0 x15_re_a2 p2 0 0.1414213562373095
Fx15_re_a2 0 x15_re_a2 V2 7.0710678118654755
Rp15_re_re_a2 0 x15_re_a2 1.2831897645969387e-10
Gp15_re_im_a2 0 x15_re_a2 x15_im_a2 0 1637376924.4051015
Cx15_im_a2 x15_im_a2 0 1.0
Gp15_im_re_a2 0 x15_im_a2 x15_re_a2 0 -1637376924.4051015
Rp15_im_im_a2 0 x15_im_a2 1.2831897645969387e-10
Cx16_a2 x16_a2 0 1.0
Gx16_a2 0 x16_a2 p2 0 0.07071067811865475
Fx16_a2 0 x16_a2 V2 3.5355339059327378
Rp16_a2 0 x16_a2 1.7778623385046862e-10
Cx17_a2 x17_a2 0 1.0
Gx17_a2 0 x17_a2 p2 0 0.07071067811865475
Fx17_a2 0 x17_a2 V2 3.5355339059327378
Rp17_a2 0 x17_a2 2.485395232504578e-10
Cx18_a2 x18_a2 0 1.0
Gx18_a2 0 x18_a2 p2 0 0.07071067811865475
Fx18_a2 0 x18_a2 V2 3.5355339059327378
Rp18_a2 0 x18_a2 4.548405682328741e-10
Cx19_a2 x19_a2 0 1.0
Gx19_a2 0 x19_a2 p2 0 0.07071067811865475
Fx19_a2 0 x19_a2 V2 3.5355339059327378
Rp19_a2 0 x19_a2 5.348783706572236e-10
Cx20_a2 x20_a2 0 1.0
Gx20_a2 0 x20_a2 p2 0 0.07071067811865475
Fx20_a2 0 x20_a2 V2 3.5355339059327378
Rp20_a2 0 x20_a2 9.219633096808902e-10
Cx21_a2 x21_a2 0 1.0
Gx21_a2 0 x21_a2 p2 0 0.07071067811865475
Fx21_a2 0 x21_a2 V2 3.5355339059327378
Rp21_a2 0 x21_a2 1.6052978415600169e-09
Cx22_a2 x22_a2 0 1.0
Gx22_a2 0 x22_a2 p2 0 0.07071067811865475
Fx22_a2 0 x22_a2 V2 3.5355339059327378
Rp22_a2 0 x22_a2 2.0052869989942374e-09
Cx23_a2 x23_a2 0 1.0
Gx23_a2 0 x23_a2 p2 0 0.07071067811865475
Fx23_a2 0 x23_a2 V2 3.5355339059327378
Rp23_a2 0 x23_a2 2.722824336602712e-09
Cx24_a2 x24_a2 0 1.0
Gx24_a2 0 x24_a2 p2 0 0.07071067811865475
Fx24_a2 0 x24_a2 V2 3.5355339059327378
Rp24_a2 0 x24_a2 3453.7657697020504
Cx25_a2 x25_a2 0 1.0
Gx25_a2 0 x25_a2 p2 0 0.07071067811865475
Fx25_a2 0 x25_a2 V2 3.5355339059327378
Rp25_a2 0 x25_a2 78355.04403096001
.ENDS s_equivalent
