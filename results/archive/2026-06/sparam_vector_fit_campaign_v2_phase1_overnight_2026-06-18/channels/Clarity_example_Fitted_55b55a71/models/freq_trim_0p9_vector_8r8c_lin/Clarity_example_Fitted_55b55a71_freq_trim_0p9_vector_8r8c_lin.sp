* EQUIVALENT CIRCUIT FOR VECTOR FITTED S-MATRIX
* Created using scikit-rf vectorFitting.py
*
.SUBCKT s_equivalent p1 p2
*
* Port network for port 1
V1 p1 s1 0
R1 s1 0 50.0
Gd1_1 0 s1 p1 0 0.01998004960876146
Fd1_1 0 s1 V1 0.9990024804380732
Gr1_re_1_1 0 s1 x1_re_a1 0 27982.20265248436
Gr1_im_1_1 0 s1 x1_im_a1 0 -361797.907442018
Gr2_re_1_1 0 s1 x2_re_a1 0 4648090610.200075
Gr2_im_1_1 0 s1 x2_im_a1 0 152627277.56652433
Gr3_re_1_1 0 s1 x3_re_a1 0 1657383377.2842712
Gr3_im_1_1 0 s1 x3_im_a1 0 -1386343579.109625
Gr4_re_1_1 0 s1 x4_re_a1 0 741.3596851387888
Gr4_im_1_1 0 s1 x4_im_a1 0 2205.7041466218125
Gr5_re_1_1 0 s1 x5_re_a1 0 6298665155.947704
Gr5_im_1_1 0 s1 x5_im_a1 0 2443854896.066587
Gr6_re_1_1 0 s1 x6_re_a1 0 8713028361.343458
Gr6_im_1_1 0 s1 x6_im_a1 0 -30674414932.331505
Gr7_re_1_1 0 s1 x7_re_a1 0 -7.178092086578874e-05
Gr7_im_1_1 0 s1 x7_im_a1 0 1.9544651468038306e-05
Gr8_1_1 0 s1 x8_a1 0 -68325836617.92175
Gr9_re_1_1 0 s1 x9_re_a1 0 -4253807378.400479
Gr9_im_1_1 0 s1 x9_im_a1 0 -89324436337.96184
Gr10_1_1 0 s1 x10_a1 0 16144400820.78793
Gr11_1_1 0 s1 x11_a1 0 -5207633054.935469
Gr12_1_1 0 s1 x12_a1 0 3581889080.3008523
Gr13_1_1 0 s1 x13_a1 0 -432697255.4454742
Gr14_1_1 0 s1 x14_a1 0 26557281.6169732
Gr15_1_1 0 s1 x15_a1 0 252075668.48040745
Gr16_1_1 0 s1 x16_a1 0 -165818925.54094332
Gd1_2 0 s1 p2 0 1.783568043224141e-08
Fd1_2 0 s1 V2 8.917840216120706e-07
Gr1_re_1_2 0 s1 x1_re_a2 0 -15827.849149463218
Gr1_im_1_2 0 s1 x1_im_a2 0 -92841.7535405913
Gr2_re_1_2 0 s1 x2_re_a2 0 -205789463.76301256
Gr2_im_1_2 0 s1 x2_im_a2 0 -4025061218.4021826
Gr3_re_1_2 0 s1 x3_re_a2 0 -1283378741.3257806
Gr3_im_1_2 0 s1 x3_im_a2 0 1114791321.407897
Gr4_re_1_2 0 s1 x4_re_a2 0 -235.73948700692216
Gr4_im_1_2 0 s1 x4_im_a2 0 -499.5997554482246
Gr5_re_1_2 0 s1 x5_re_a2 0 -6338417084.303084
Gr5_im_1_2 0 s1 x5_im_a2 0 6440952013.634399
Gr6_re_1_2 0 s1 x6_re_a2 0 3845902764.919192
Gr6_im_1_2 0 s1 x6_im_a2 0 1984259913.9226534
Gr7_re_1_2 0 s1 x7_re_a2 0 -4.441950928820027e-06
Gr7_im_1_2 0 s1 x7_im_a2 0 -1.3869807789457795e-05
Gr8_1_2 0 s1 x8_a2 0 2640151765.2149076
Gr9_re_1_2 0 s1 x9_re_a2 0 3875549313.374911
Gr9_im_1_2 0 s1 x9_im_a2 0 -3426240814.2748213
Gr10_1_2 0 s1 x10_a2 0 -2597662430.3032894
Gr11_1_2 0 s1 x11_a2 0 2365524168.2159066
Gr12_1_2 0 s1 x12_a2 0 -1909525534.4626484
Gr13_1_2 0 s1 x13_a2 0 350516592.8243939
Gr14_1_2 0 s1 x14_a2 0 -40919371.97473314
Gr15_1_2 0 s1 x15_a2 0 -286579255.11770314
Gr16_1_2 0 s1 x16_a2 0 214674195.41493693
*
* State networks driven by port 1
Cx1_re_a1 x1_re_a1 0 1.0
Gx1_re_a1 0 x1_re_a1 p1 0 0.1414213562373095
Fx1_re_a1 0 x1_re_a1 V1 7.0710678118654755
Rp1_re_re_a1 0 x1_re_a1 1.6275593097529748e-11
Gp1_re_im_a1 0 x1_re_a1 x1_im_a1 0 36148742346.97618
Cx1_im_a1 x1_im_a1 0 1.0
Gp1_im_re_a1 0 x1_im_a1 x1_re_a1 0 -36148742346.97618
Rp1_im_im_a1 0 x1_im_a1 1.6275593097529748e-11
Cx2_re_a1 x2_re_a1 0 1.0
Gx2_re_a1 0 x2_re_a1 p1 0 0.1414213562373095
Fx2_re_a1 0 x2_re_a1 V1 7.0710678118654755
Rp2_re_re_a1 0 x2_re_a1 1.5798057718511304e-10
Gp2_re_im_a1 0 x2_re_a1 x2_im_a1 0 18767842977.117542
Cx2_im_a1 x2_im_a1 0 1.0
Gp2_im_re_a1 0 x2_im_a1 x2_re_a1 0 -18767842977.117542
Rp2_im_im_a1 0 x2_im_a1 1.5798057718511304e-10
Cx3_re_a1 x3_re_a1 0 1.0
Gx3_re_a1 0 x3_re_a1 p1 0 0.1414213562373095
Fx3_re_a1 0 x3_re_a1 V1 7.0710678118654755
Rp3_re_re_a1 0 x3_re_a1 1.7986266288542476e-10
Gp3_re_im_a1 0 x3_re_a1 x3_im_a1 0 13980083516.210443
Cx3_im_a1 x3_im_a1 0 1.0
Gp3_im_re_a1 0 x3_im_a1 x3_re_a1 0 -13980083516.210443
Rp3_im_im_a1 0 x3_im_a1 1.7986266288542476e-10
Cx4_re_a1 x4_re_a1 0 1.0
Gx4_re_a1 0 x4_re_a1 p1 0 0.1414213562373095
Fx4_re_a1 0 x4_re_a1 V1 7.0710678118654755
Rp4_re_re_a1 0 x4_re_a1 1.7794994608285597e-10
Gp4_re_im_a1 0 x4_re_a1 x4_im_a1 0 11409875898.195827
Cx4_im_a1 x4_im_a1 0 1.0
Gp4_im_re_a1 0 x4_im_a1 x4_re_a1 0 -11409875898.195827
Rp4_im_im_a1 0 x4_im_a1 1.7794994608285597e-10
Cx5_re_a1 x5_re_a1 0 1.0
Gx5_re_a1 0 x5_re_a1 p1 0 0.1414213562373095
Fx5_re_a1 0 x5_re_a1 V1 7.0710678118654755
Rp5_re_re_a1 0 x5_re_a1 1.2873585205344103e-10
Gp5_re_im_a1 0 x5_re_a1 x5_im_a1 0 10094507172.486635
Cx5_im_a1 x5_im_a1 0 1.0
Gp5_im_re_a1 0 x5_im_a1 x5_re_a1 0 -10094507172.486635
Rp5_im_im_a1 0 x5_im_a1 1.2873585205344103e-10
Cx6_re_a1 x6_re_a1 0 1.0
Gx6_re_a1 0 x6_re_a1 p1 0 0.1414213562373095
Fx6_re_a1 0 x6_re_a1 V1 7.0710678118654755
Rp6_re_re_a1 0 x6_re_a1 1.0605743747631015e-10
Gp6_re_im_a1 0 x6_re_a1 x6_im_a1 0 7055400717.071072
Cx6_im_a1 x6_im_a1 0 1.0
Gp6_im_re_a1 0 x6_im_a1 x6_re_a1 0 -7055400717.071072
Rp6_im_im_a1 0 x6_im_a1 1.0605743747631015e-10
Cx7_re_a1 x7_re_a1 0 1.0
Gx7_re_a1 0 x7_re_a1 p1 0 0.1414213562373095
Fx7_re_a1 0 x7_re_a1 V1 7.0710678118654755
Rp7_re_re_a1 0 x7_re_a1 8.725230241112217e-10
Gp7_re_im_a1 0 x7_re_a1 x7_im_a1 0 7561360731.724007
Cx7_im_a1 x7_im_a1 0 1.0
Gp7_im_re_a1 0 x7_im_a1 x7_re_a1 0 -7561360731.724007
Rp7_im_im_a1 0 x7_im_a1 8.725230241112217e-10
Cx8_a1 x8_a1 0 1.0
Gx8_a1 0 x8_a1 p1 0 0.07071067811865475
Fx8_a1 0 x8_a1 V1 3.5355339059327378
Rp8_a1 0 x8_a1 1.777850187996399e-10
Cx9_re_a1 x9_re_a1 0 1.0
Gx9_re_a1 0 x9_re_a1 p1 0 0.1414213562373095
Fx9_re_a1 0 x9_re_a1 V1 7.0710678118654755
Rp9_re_re_a1 0 x9_re_a1 1.2831945851472814e-10
Gp9_re_im_a1 0 x9_re_a1 x9_im_a1 0 1637219322.3226275
Cx9_im_a1 x9_im_a1 0 1.0
Gp9_im_re_a1 0 x9_im_a1 x9_re_a1 0 -1637219322.3226275
Rp9_im_im_a1 0 x9_im_a1 1.2831945851472814e-10
Cx10_a1 x10_a1 0 1.0
Gx10_a1 0 x10_a1 p1 0 0.07071067811865475
Fx10_a1 0 x10_a1 V1 3.5355339059327378
Rp10_a1 0 x10_a1 2.4853978606877725e-10
Cx11_a1 x11_a1 0 1.0
Gx11_a1 0 x11_a1 p1 0 0.07071067811865475
Fx11_a1 0 x11_a1 V1 3.5355339059327378
Rp11_a1 0 x11_a1 4.548404513075579e-10
Cx12_a1 x12_a1 0 1.0
Gx12_a1 0 x12_a1 p1 0 0.07071067811865475
Fx12_a1 0 x12_a1 V1 3.5355339059327378
Rp12_a1 0 x12_a1 5.348784719584691e-10
Cx13_a1 x13_a1 0 1.0
Gx13_a1 0 x13_a1 p1 0 0.07071067811865475
Fx13_a1 0 x13_a1 V1 3.5355339059327378
Rp13_a1 0 x13_a1 9.219632648142649e-10
Cx14_a1 x14_a1 0 1.0
Gx14_a1 0 x14_a1 p1 0 0.07071067811865475
Fx14_a1 0 x14_a1 V1 3.5355339059327378
Rp14_a1 0 x14_a1 2.7228244700200523e-09
Cx15_a1 x15_a1 0 1.0
Gx15_a1 0 x15_a1 p1 0 0.07071067811865475
Fx15_a1 0 x15_a1 V1 3.5355339059327378
Rp15_a1 0 x15_a1 1.6052980181313327e-09
Cx16_a1 x16_a1 0 1.0
Gx16_a1 0 x16_a1 p1 0 0.07071067811865475
Fx16_a1 0 x16_a1 V1 3.5355339059327378
Rp16_a1 0 x16_a1 2.00528673365549e-09
*
* Port network for port 2
V2 p2 s2 0
R2 s2 0 50.0
Gd2_1 0 s2 p1 0 1.783568043224141e-08
Fd2_1 0 s2 V1 8.917840216120706e-07
Gr1_re_2_1 0 s2 x1_re_a1 0 -15827.849149463218
Gr1_im_2_1 0 s2 x1_im_a1 0 -92841.7535405913
Gr2_re_2_1 0 s2 x2_re_a1 0 -205789463.76301256
Gr2_im_2_1 0 s2 x2_im_a1 0 -4025061218.4021826
Gr3_re_2_1 0 s2 x3_re_a1 0 -1283378741.3257806
Gr3_im_2_1 0 s2 x3_im_a1 0 1114791321.407897
Gr4_re_2_1 0 s2 x4_re_a1 0 -235.73948700692216
Gr4_im_2_1 0 s2 x4_im_a1 0 -499.5997554482246
Gr5_re_2_1 0 s2 x5_re_a1 0 -6338417084.303084
Gr5_im_2_1 0 s2 x5_im_a1 0 6440952013.634399
Gr6_re_2_1 0 s2 x6_re_a1 0 3845902764.919192
Gr6_im_2_1 0 s2 x6_im_a1 0 1984259913.9226534
Gr7_re_2_1 0 s2 x7_re_a1 0 -4.441950928820027e-06
Gr7_im_2_1 0 s2 x7_im_a1 0 -1.3869807789457795e-05
Gr8_2_1 0 s2 x8_a1 0 2640151765.2149076
Gr9_re_2_1 0 s2 x9_re_a1 0 3875549313.374911
Gr9_im_2_1 0 s2 x9_im_a1 0 -3426240814.2748213
Gr10_2_1 0 s2 x10_a1 0 -2597662430.3032894
Gr11_2_1 0 s2 x11_a1 0 2365524168.2159066
Gr12_2_1 0 s2 x12_a1 0 -1909525534.4626484
Gr13_2_1 0 s2 x13_a1 0 350516592.8243939
Gr14_2_1 0 s2 x14_a1 0 -40919371.97473314
Gr15_2_1 0 s2 x15_a1 0 -286579255.11770314
Gr16_2_1 0 s2 x16_a1 0 214674195.41493693
Gd2_2 0 s2 p2 0 0.019980048873919236
Fd2_2 0 s2 V2 0.9990024436959619
Gr1_re_2_2 0 s2 x1_re_a2 0 28142.832731583992
Gr1_im_2_2 0 s2 x1_im_a2 0 -358001.8957694681
Gr2_re_2_2 0 s2 x2_re_a2 0 4727909989.652743
Gr2_im_2_2 0 s2 x2_im_a2 0 52396358.00424249
Gr3_re_2_2 0 s2 x3_re_a2 0 1642324073.776584
Gr3_im_2_2 0 s2 x3_im_a2 0 -1435103466.1866305
Gr4_re_2_2 0 s2 x4_re_a2 0 848.7479333118582
Gr4_im_2_2 0 s2 x4_im_a2 0 2166.896581600428
Gr5_re_2_2 0 s2 x5_re_a2 0 6096502924.05288
Gr5_im_2_2 0 s2 x5_im_a2 0 2089344075.9466648
Gr6_re_2_2 0 s2 x6_re_a2 0 8097110661.42546
Gr6_im_2_2 0 s2 x6_im_a2 0 -29863838419.146957
Gr7_re_2_2 0 s2 x7_re_a2 0 -4.3718894988875624e-05
Gr7_im_2_2 0 s2 x7_im_a2 0 2.733084300200654e-05
Gr8_2_2 0 s2 x8_a2 0 -67329617519.31811
Gr9_re_2_2 0 s2 x9_re_a2 0 -3931480012.8147206
Gr9_im_2_2 0 s2 x9_im_a2 0 -87338944413.49513
Gr10_2_2 0 s2 x10_a2 0 16016840335.041077
Gr11_2_2 0 s2 x11_a2 0 -5201218596.1320305
Gr12_2_2 0 s2 x12_a2 0 3580297984.4118752
Gr13_2_2 0 s2 x13_a2 0 -432997571.8901063
Gr14_2_2 0 s2 x14_a2 0 26573669.721560687
Gr15_2_2 0 s2 x15_a2 0 252277040.68325517
Gr16_2_2 0 s2 x16_a2 0 -165941200.9081294
*
* State networks driven by port 2
Cx1_re_a2 x1_re_a2 0 1.0
Gx1_re_a2 0 x1_re_a2 p2 0 0.1414213562373095
Fx1_re_a2 0 x1_re_a2 V2 7.0710678118654755
Rp1_re_re_a2 0 x1_re_a2 1.6275593097529748e-11
Gp1_re_im_a2 0 x1_re_a2 x1_im_a2 0 36148742346.97618
Cx1_im_a2 x1_im_a2 0 1.0
Gp1_im_re_a2 0 x1_im_a2 x1_re_a2 0 -36148742346.97618
Rp1_im_im_a2 0 x1_im_a2 1.6275593097529748e-11
Cx2_re_a2 x2_re_a2 0 1.0
Gx2_re_a2 0 x2_re_a2 p2 0 0.1414213562373095
Fx2_re_a2 0 x2_re_a2 V2 7.0710678118654755
Rp2_re_re_a2 0 x2_re_a2 1.5798057718511304e-10
Gp2_re_im_a2 0 x2_re_a2 x2_im_a2 0 18767842977.117542
Cx2_im_a2 x2_im_a2 0 1.0
Gp2_im_re_a2 0 x2_im_a2 x2_re_a2 0 -18767842977.117542
Rp2_im_im_a2 0 x2_im_a2 1.5798057718511304e-10
Cx3_re_a2 x3_re_a2 0 1.0
Gx3_re_a2 0 x3_re_a2 p2 0 0.1414213562373095
Fx3_re_a2 0 x3_re_a2 V2 7.0710678118654755
Rp3_re_re_a2 0 x3_re_a2 1.7986266288542476e-10
Gp3_re_im_a2 0 x3_re_a2 x3_im_a2 0 13980083516.210443
Cx3_im_a2 x3_im_a2 0 1.0
Gp3_im_re_a2 0 x3_im_a2 x3_re_a2 0 -13980083516.210443
Rp3_im_im_a2 0 x3_im_a2 1.7986266288542476e-10
Cx4_re_a2 x4_re_a2 0 1.0
Gx4_re_a2 0 x4_re_a2 p2 0 0.1414213562373095
Fx4_re_a2 0 x4_re_a2 V2 7.0710678118654755
Rp4_re_re_a2 0 x4_re_a2 1.7794994608285597e-10
Gp4_re_im_a2 0 x4_re_a2 x4_im_a2 0 11409875898.195827
Cx4_im_a2 x4_im_a2 0 1.0
Gp4_im_re_a2 0 x4_im_a2 x4_re_a2 0 -11409875898.195827
Rp4_im_im_a2 0 x4_im_a2 1.7794994608285597e-10
Cx5_re_a2 x5_re_a2 0 1.0
Gx5_re_a2 0 x5_re_a2 p2 0 0.1414213562373095
Fx5_re_a2 0 x5_re_a2 V2 7.0710678118654755
Rp5_re_re_a2 0 x5_re_a2 1.2873585205344103e-10
Gp5_re_im_a2 0 x5_re_a2 x5_im_a2 0 10094507172.486635
Cx5_im_a2 x5_im_a2 0 1.0
Gp5_im_re_a2 0 x5_im_a2 x5_re_a2 0 -10094507172.486635
Rp5_im_im_a2 0 x5_im_a2 1.2873585205344103e-10
Cx6_re_a2 x6_re_a2 0 1.0
Gx6_re_a2 0 x6_re_a2 p2 0 0.1414213562373095
Fx6_re_a2 0 x6_re_a2 V2 7.0710678118654755
Rp6_re_re_a2 0 x6_re_a2 1.0605743747631015e-10
Gp6_re_im_a2 0 x6_re_a2 x6_im_a2 0 7055400717.071072
Cx6_im_a2 x6_im_a2 0 1.0
Gp6_im_re_a2 0 x6_im_a2 x6_re_a2 0 -7055400717.071072
Rp6_im_im_a2 0 x6_im_a2 1.0605743747631015e-10
Cx7_re_a2 x7_re_a2 0 1.0
Gx7_re_a2 0 x7_re_a2 p2 0 0.1414213562373095
Fx7_re_a2 0 x7_re_a2 V2 7.0710678118654755
Rp7_re_re_a2 0 x7_re_a2 8.725230241112217e-10
Gp7_re_im_a2 0 x7_re_a2 x7_im_a2 0 7561360731.724007
Cx7_im_a2 x7_im_a2 0 1.0
Gp7_im_re_a2 0 x7_im_a2 x7_re_a2 0 -7561360731.724007
Rp7_im_im_a2 0 x7_im_a2 8.725230241112217e-10
Cx8_a2 x8_a2 0 1.0
Gx8_a2 0 x8_a2 p2 0 0.07071067811865475
Fx8_a2 0 x8_a2 V2 3.5355339059327378
Rp8_a2 0 x8_a2 1.777850187996399e-10
Cx9_re_a2 x9_re_a2 0 1.0
Gx9_re_a2 0 x9_re_a2 p2 0 0.1414213562373095
Fx9_re_a2 0 x9_re_a2 V2 7.0710678118654755
Rp9_re_re_a2 0 x9_re_a2 1.2831945851472814e-10
Gp9_re_im_a2 0 x9_re_a2 x9_im_a2 0 1637219322.3226275
Cx9_im_a2 x9_im_a2 0 1.0
Gp9_im_re_a2 0 x9_im_a2 x9_re_a2 0 -1637219322.3226275
Rp9_im_im_a2 0 x9_im_a2 1.2831945851472814e-10
Cx10_a2 x10_a2 0 1.0
Gx10_a2 0 x10_a2 p2 0 0.07071067811865475
Fx10_a2 0 x10_a2 V2 3.5355339059327378
Rp10_a2 0 x10_a2 2.4853978606877725e-10
Cx11_a2 x11_a2 0 1.0
Gx11_a2 0 x11_a2 p2 0 0.07071067811865475
Fx11_a2 0 x11_a2 V2 3.5355339059327378
Rp11_a2 0 x11_a2 4.548404513075579e-10
Cx12_a2 x12_a2 0 1.0
Gx12_a2 0 x12_a2 p2 0 0.07071067811865475
Fx12_a2 0 x12_a2 V2 3.5355339059327378
Rp12_a2 0 x12_a2 5.348784719584691e-10
Cx13_a2 x13_a2 0 1.0
Gx13_a2 0 x13_a2 p2 0 0.07071067811865475
Fx13_a2 0 x13_a2 V2 3.5355339059327378
Rp13_a2 0 x13_a2 9.219632648142649e-10
Cx14_a2 x14_a2 0 1.0
Gx14_a2 0 x14_a2 p2 0 0.07071067811865475
Fx14_a2 0 x14_a2 V2 3.5355339059327378
Rp14_a2 0 x14_a2 2.7228244700200523e-09
Cx15_a2 x15_a2 0 1.0
Gx15_a2 0 x15_a2 p2 0 0.07071067811865475
Fx15_a2 0 x15_a2 V2 3.5355339059327378
Rp15_a2 0 x15_a2 1.6052980181313327e-09
Cx16_a2 x16_a2 0 1.0
Gx16_a2 0 x16_a2 p2 0 0.07071067811865475
Fx16_a2 0 x16_a2 V2 3.5355339059327378
Rp16_a2 0 x16_a2 2.00528673365549e-09
.ENDS s_equivalent
