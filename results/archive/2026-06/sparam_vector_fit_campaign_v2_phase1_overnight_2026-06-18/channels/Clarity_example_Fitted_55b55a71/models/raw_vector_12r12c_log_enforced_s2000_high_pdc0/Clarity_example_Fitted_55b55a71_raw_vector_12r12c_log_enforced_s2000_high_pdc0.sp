* EQUIVALENT CIRCUIT FOR VECTOR FITTED S-MATRIX
* Created using scikit-rf vectorFitting.py
*
.SUBCKT s_equivalent p1 p2
*
* Port network for port 1
V1 p1 s1 0
R1 s1 0 50.0
Gd1_1 0 s1 p1 0 0.019992185670763003
Fd1_1 0 s1 V1 0.9996092835381503
Gr1_1_1 0 s1 x1_a1 0 -246554502.47286475
Gr2_1_1 0 s1 x2_a1 0 13170244.278780883
Gr3_re_1_1 0 s1 x3_re_a1 0 4647984108.980737
Gr3_im_1_1 0 s1 x3_im_a1 0 152618982.53930825
Gr4_re_1_1 0 s1 x4_re_a1 0 1657354188.917401
Gr4_im_1_1 0 s1 x4_im_a1 0 -1386368009.77827
Gr5_re_1_1 0 s1 x5_re_a1 0 93597266.23691249
Gr5_im_1_1 0 s1 x5_im_a1 0 -35295675.89765984
Gr6_re_1_1 0 s1 x6_re_a1 0 6298987986.577174
Gr6_im_1_1 0 s1 x6_im_a1 0 2443935445.584987
Gr7_re_1_1 0 s1 x7_re_a1 0 8695053068.407377
Gr7_im_1_1 0 s1 x7_im_a1 0 -30706189585.871067
Gr8_re_1_1 0 s1 x8_re_a1 0 -4602118812.644001
Gr8_im_1_1 0 s1 x8_im_a1 0 -89168779899.91418
Gr9_re_1_1 0 s1 x9_re_a1 0 0.0001680708190681752
Gr9_im_1_1 0 s1 x9_im_a1 0 -3.668553617825942e-05
Gr10_1_1 0 s1 x10_a1 0 -68285626445.35353
Gr11_1_1 0 s1 x11_a1 0 12231190778.772366
Gr12_1_1 0 s1 x12_a1 0 4445188318.952077
Gr13_re_1_1 0 s1 x13_re_a1 0 -0.000812432135453043
Gr13_im_1_1 0 s1 x13_im_a1 0 0.00027219221172710106
Gr14_1_1 0 s1 x14_a1 0 -4696041244.189468
Gr15_1_1 0 s1 x15_a1 0 3100183164.5683117
Gr16_re_1_1 0 s1 x16_re_a1 0 0.0024621341497432403
Gr16_im_1_1 0 s1 x16_im_a1 0 0.5148516200400268
Gr17_1_1 0 s1 x17_a1 0 -116718880.64686
Gr18_re_1_1 0 s1 x18_re_a1 0 -12.58513476812583
Gr18_im_1_1 0 s1 x18_im_a1 0 -3.990504428288366
Gr19_1_1 0 s1 x19_a1 0 -366003338.06007886
Gr20_re_1_1 0 s1 x20_re_a1 0 5.943256623117844
Gr20_im_1_1 0 s1 x20_im_a1 0 4.689632087242555
Gr21_re_1_1 0 s1 x21_re_a1 0 50883827.73179529
Gr21_im_1_1 0 s1 x21_im_a1 0 61791050.36339097
Gr22_re_1_1 0 s1 x22_re_a1 0 -489031.0342960318
Gr22_im_1_1 0 s1 x22_im_a1 0 -563119.8920126177
Gr23_1_1 0 s1 x23_a1 0 2648682.952297255
Gd1_2 0 s1 p2 0 4.887474167978572e-06
Fd1_2 0 s1 V2 0.00024437370839892864
Gr1_1_2 0 s1 x1_a2 0 -96929380.59289226
Gr2_1_2 0 s1 x2_a2 0 4355478.714857176
Gr3_re_1_2 0 s1 x3_re_a2 0 -205781154.17098373
Gr3_im_1_2 0 s1 x3_im_a2 0 -4024987785.2861524
Gr4_re_1_2 0 s1 x4_re_a2 0 -1283361436.2776947
Gr4_im_1_2 0 s1 x4_im_a2 0 1114811718.674628
Gr5_re_1_2 0 s1 x5_re_a2 0 2135142.2000102056
Gr5_im_1_2 0 s1 x5_im_a2 0 -469757.05332205904
Gr6_re_1_2 0 s1 x6_re_a2 0 -6338581196.170528
Gr6_im_1_2 0 s1 x6_im_a2 0 6441008552.128779
Gr7_re_1_2 0 s1 x7_re_a2 0 3849032568.8987355
Gr7_im_1_2 0 s1 x7_im_a2 0 1983274651.6470132
Gr8_re_1_2 0 s1 x8_re_a2 0 3871405120.929607
Gr8_im_1_2 0 s1 x8_im_a2 0 -3447986043.9645886
Gr9_re_1_2 0 s1 x9_re_a2 0 -0.00010268486079439182
Gr9_im_1_2 0 s1 x9_im_a2 0 5.7237828857655e-05
Gr10_1_2 0 s1 x10_a2 0 2682278379.099439
Gr11_1_2 0 s1 x11_a2 0 -1852767830.533037
Gr12_1_2 0 s1 x12_a2 0 -799066519.2432361
Gr13_re_1_2 0 s1 x13_re_a2 0 0.0004965414429479107
Gr13_im_1_2 0 s1 x13_im_a2 0 0.00016731383595684554
Gr14_1_2 0 s1 x14_a2 0 2108306673.486467
Gr15_1_2 0 s1 x15_a2 0 -1681278520.763714
Gr16_re_1_2 0 s1 x16_re_a2 0 0.3191262376084948
Gr16_im_1_2 0 s1 x16_im_a2 0 -0.3307917299249794
Gr17_1_2 0 s1 x17_a2 0 81520591.03844175
Gr18_re_1_2 0 s1 x18_re_a2 0 6.53210414771711
Gr18_im_1_2 0 s1 x18_im_a2 0 11.608900214844537
Gr19_1_2 0 s1 x19_a2 0 299303348.3128662
Gr20_re_1_2 0 s1 x20_re_a2 0 -0.5167535978561497
Gr20_im_1_2 0 s1 x20_im_a2 0 -9.057446695918484
Gr21_re_1_2 0 s1 x21_re_a2 0 -50514763.7354806
Gr21_im_1_2 0 s1 x21_im_a2 0 -77113893.84164181
Gr22_re_1_2 0 s1 x22_re_a2 0 529348.5868858114
Gr22_im_1_2 0 s1 x22_im_a2 0 1080536.0208259341
Gr23_1_2 0 s1 x23_a2 0 -4704064.580412706
*
* State networks driven by port 1
Cx1_a1 x1_a1 0 1.0
Gx1_a1 0 x1_a1 p1 0 0.07071067811865475
Fx1_a1 0 x1_a1 V1 3.5355339059327378
Rp1_a1 0 x1_a1 9.442076531440238e-13
Cx2_a1 x2_a1 0 1.0
Gx2_a1 0 x2_a1 p1 0 0.07071067811865475
Fx2_a1 0 x2_a1 V1 3.5355339059327378
Rp2_a1 0 x2_a1 8.119689655276655e-12
Cx3_re_a1 x3_re_a1 0 1.0
Gx3_re_a1 0 x3_re_a1 p1 0 0.1414213562373095
Fx3_re_a1 0 x3_re_a1 V1 7.0710678118654755
Rp3_re_re_a1 0 x3_re_a1 1.5798119894520322e-10
Gp3_re_im_a1 0 x3_re_a1 x3_im_a1 0 18767845883.733086
Cx3_im_a1 x3_im_a1 0 1.0
Gp3_im_re_a1 0 x3_im_a1 x3_re_a1 0 -18767845883.733086
Rp3_im_im_a1 0 x3_im_a1 1.5798119894520322e-10
Cx4_re_a1 x4_re_a1 0 1.0
Gx4_re_a1 0 x4_re_a1 p1 0 0.1414213562373095
Fx4_re_a1 0 x4_re_a1 V1 7.0710678118654755
Rp4_re_re_a1 0 x4_re_a1 1.7986273790456735e-10
Gp4_re_im_a1 0 x4_re_a1 x4_im_a1 0 13980092291.18969
Cx4_im_a1 x4_im_a1 0 1.0
Gp4_im_re_a1 0 x4_im_a1 x4_re_a1 0 -13980092291.18969
Rp4_im_im_a1 0 x4_im_a1 1.7986273790456735e-10
Cx5_re_a1 x5_re_a1 0 1.0
Gx5_re_a1 0 x5_re_a1 p1 0 0.1414213562373095
Fx5_re_a1 0 x5_re_a1 V1 7.0710678118654755
Rp5_re_re_a1 0 x5_re_a1 6.97718138849149e-11
Gp5_re_im_a1 0 x5_re_a1 x5_im_a1 0 5082871638.868746
Cx5_im_a1 x5_im_a1 0 1.0
Gp5_im_re_a1 0 x5_im_a1 x5_re_a1 0 -5082871638.868746
Rp5_im_im_a1 0 x5_im_a1 6.97718138849149e-11
Cx6_re_a1 x6_re_a1 0 1.0
Gx6_re_a1 0 x6_re_a1 p1 0 0.1414213562373095
Fx6_re_a1 0 x6_re_a1 V1 7.0710678118654755
Rp6_re_re_a1 0 x6_re_a1 1.2873579232108604e-10
Gp6_re_im_a1 0 x6_re_a1 x6_im_a1 0 10094502597.60111
Cx6_im_a1 x6_im_a1 0 1.0
Gp6_im_re_a1 0 x6_im_a1 x6_re_a1 0 -10094502597.60111
Rp6_im_im_a1 0 x6_im_a1 1.2873579232108604e-10
Cx7_re_a1 x7_re_a1 0 1.0
Gx7_re_a1 0 x7_re_a1 p1 0 0.1414213562373095
Fx7_re_a1 0 x7_re_a1 V1 7.0710678118654755
Rp7_re_re_a1 0 x7_re_a1 1.060466258107134e-10
Gp7_re_im_a1 0 x7_re_a1 x7_im_a1 0 7055729674.51677
Cx7_im_a1 x7_im_a1 0 1.0
Gp7_im_re_a1 0 x7_im_a1 x7_re_a1 0 -7055729674.51677
Rp7_im_im_a1 0 x7_im_a1 1.060466258107134e-10
Cx8_re_a1 x8_re_a1 0 1.0
Gx8_re_a1 0 x8_re_a1 p1 0 0.1414213562373095
Fx8_re_a1 0 x8_re_a1 V1 7.0710678118654755
Rp8_re_re_a1 0 x8_re_a1 1.2824551237449797e-10
Gp8_re_im_a1 0 x8_re_a1 x8_im_a1 0 1639001901.8720396
Cx8_im_a1 x8_im_a1 0 1.0
Gp8_im_re_a1 0 x8_im_a1 x8_re_a1 0 -1639001901.8720396
Rp8_im_im_a1 0 x8_im_a1 1.2824551237449797e-10
Cx9_re_a1 x9_re_a1 0 1.0
Gx9_re_a1 0 x9_re_a1 p1 0 0.1414213562373095
Fx9_re_a1 0 x9_re_a1 V1 7.0710678118654755
Rp9_re_re_a1 0 x9_re_a1 9.666847813637946e-10
Gp9_re_im_a1 0 x9_re_a1 x9_im_a1 0 5979089146.140133
Cx9_im_a1 x9_im_a1 0 1.0
Gp9_im_re_a1 0 x9_im_a1 x9_re_a1 0 -5979089146.140133
Rp9_im_im_a1 0 x9_im_a1 9.666847813637946e-10
Cx10_a1 x10_a1 0 1.0
Gx10_a1 0 x10_a1 p1 0 0.07071067811865475
Fx10_a1 0 x10_a1 V1 3.5355339059327378
Rp10_a1 0 x10_a1 1.782623803782255e-10
Cx11_a1 x11_a1 0 1.0
Gx11_a1 0 x11_a1 p1 0 0.07071067811865475
Fx11_a1 0 x11_a1 V1 3.5355339059327378
Rp11_a1 0 x11_a1 2.4338190879608553e-10
Cx12_a1 x12_a1 0 1.0
Gx12_a1 0 x12_a1 p1 0 0.07071067811865475
Fx12_a1 0 x12_a1 V1 3.5355339059327378
Rp12_a1 0 x12_a1 2.5897002726286557e-10
Cx13_re_a1 x13_re_a1 0 1.0
Gx13_re_a1 0 x13_re_a1 p1 0 0.1414213562373095
Fx13_re_a1 0 x13_re_a1 V1 7.0710678118654755
Rp13_re_re_a1 0 x13_re_a1 1.8162817414561346e-09
Gp13_re_im_a1 0 x13_re_a1 x13_im_a1 0 2497837479.278144
Cx13_im_a1 x13_im_a1 0 1.0
Gp13_im_re_a1 0 x13_im_a1 x13_re_a1 0 -2497837479.278144
Rp13_im_im_a1 0 x13_im_a1 1.8162817414561346e-09
Cx14_a1 x14_a1 0 1.0
Gx14_a1 0 x14_a1 p1 0 0.07071067811865475
Fx14_a1 0 x14_a1 V1 3.5355339059327378
Rp14_a1 0 x14_a1 4.4993091661383564e-10
Cx15_a1 x15_a1 0 1.0
Gx15_a1 0 x15_a1 p1 0 0.07071067811865475
Fx15_a1 0 x15_a1 V1 3.5355339059327378
Rp15_a1 0 x15_a1 5.450887754769265e-10
Cx16_re_a1 x16_re_a1 0 1.0
Gx16_re_a1 0 x16_re_a1 p1 0 0.1414213562373095
Fx16_re_a1 0 x16_re_a1 V1 7.0710678118654755
Rp16_re_re_a1 0 x16_re_a1 5.151942745762834e-09
Gp16_re_im_a1 0 x16_re_a1 x16_im_a1 0 1093458614.9636781
Cx16_im_a1 x16_im_a1 0 1.0
Gp16_im_re_a1 0 x16_im_a1 x16_re_a1 0 -1093458614.9636781
Rp16_im_im_a1 0 x16_im_a1 5.151942745762834e-09
Cx17_a1 x17_a1 0 1.0
Gx17_a1 0 x17_a1 p1 0 0.07071067811865475
Fx17_a1 0 x17_a1 V1 3.5355339059327378
Rp17_a1 0 x17_a1 7.468174905395952e-10
Cx18_re_a1 x18_re_a1 0 1.0
Gx18_re_a1 0 x18_re_a1 p1 0 0.1414213562373095
Fx18_re_a1 0 x18_re_a1 V1 7.0710678118654755
Rp18_re_re_a1 0 x18_re_a1 5.801413313943193e-09
Gp18_re_im_a1 0 x18_re_a1 x18_im_a1 0 801740987.1040207
Cx18_im_a1 x18_im_a1 0 1.0
Gp18_im_re_a1 0 x18_im_a1 x18_re_a1 0 -801740987.1040207
Rp18_im_im_a1 0 x18_im_a1 5.801413313943193e-09
Cx19_a1 x19_a1 0 1.0
Gx19_a1 0 x19_a1 p1 0 0.07071067811865475
Fx19_a1 0 x19_a1 V1 3.5355339059327378
Rp19_a1 0 x19_a1 9.34521390895619e-10
Cx20_re_a1 x20_re_a1 0 1.0
Gx20_re_a1 0 x20_re_a1 p1 0 0.1414213562373095
Fx20_re_a1 0 x20_re_a1 V1 7.0710678118654755
Rp20_re_re_a1 0 x20_re_a1 2.5104948968726765e-08
Gp20_re_im_a1 0 x20_re_a1 x20_im_a1 0 563429512.1737212
Cx20_im_a1 x20_im_a1 0 1.0
Gp20_im_re_a1 0 x20_im_a1 x20_re_a1 0 -563429512.1737212
Rp20_im_im_a1 0 x20_im_a1 2.5104948968726765e-08
Cx21_re_a1 x21_re_a1 0 1.0
Gx21_re_a1 0 x21_re_a1 p1 0 0.1414213562373095
Fx21_re_a1 0 x21_re_a1 V1 7.0710678118654755
Rp21_re_re_a1 0 x21_re_a1 1.6655982964260597e-09
Gp21_re_im_a1 0 x21_re_a1 x21_im_a1 0 112285982.4827143
Cx21_im_a1 x21_im_a1 0 1.0
Gp21_im_re_a1 0 x21_im_a1 x21_re_a1 0 -112285982.4827143
Rp21_im_im_a1 0 x21_im_a1 1.6655982964260597e-09
Cx22_re_a1 x22_re_a1 0 1.0
Gx22_re_a1 0 x22_re_a1 p1 0 0.1414213562373095
Fx22_re_a1 0 x22_re_a1 V1 7.0710678118654755
Rp22_re_re_a1 0 x22_re_a1 3.2724352090476573e-09
Gp22_re_im_a1 0 x22_re_a1 x22_im_a1 0 153024970.97965515
Cx22_im_a1 x22_im_a1 0 1.0
Gp22_im_re_a1 0 x22_im_a1 x22_re_a1 0 -153024970.97965515
Rp22_im_im_a1 0 x22_im_a1 3.2724352090476573e-09
Cx23_a1 x23_a1 0 1.0
Gx23_a1 0 x23_a1 p1 0 0.07071067811865475
Fx23_a1 0 x23_a1 V1 3.5355339059327378
Rp23_a1 0 x23_a1 3.519195694355655e-09
*
* Port network for port 2
V2 p2 s2 0
R2 s2 0 50.0
Gd2_1 0 s2 p1 0 4.887474167978572e-06
Fd2_1 0 s2 V1 0.00024437370839892864
Gr1_2_1 0 s2 x1_a1 0 -96929380.59289226
Gr2_2_1 0 s2 x2_a1 0 4355478.714857176
Gr3_re_2_1 0 s2 x3_re_a1 0 -205781154.17098373
Gr3_im_2_1 0 s2 x3_im_a1 0 -4024987785.2861524
Gr4_re_2_1 0 s2 x4_re_a1 0 -1283361436.2776947
Gr4_im_2_1 0 s2 x4_im_a1 0 1114811718.674628
Gr5_re_2_1 0 s2 x5_re_a1 0 2135142.2000102056
Gr5_im_2_1 0 s2 x5_im_a1 0 -469757.05332205904
Gr6_re_2_1 0 s2 x6_re_a1 0 -6338581196.170528
Gr6_im_2_1 0 s2 x6_im_a1 0 6441008552.128779
Gr7_re_2_1 0 s2 x7_re_a1 0 3849032568.8987355
Gr7_im_2_1 0 s2 x7_im_a1 0 1983274651.6470132
Gr8_re_2_1 0 s2 x8_re_a1 0 3871405120.929607
Gr8_im_2_1 0 s2 x8_im_a1 0 -3447986043.9645886
Gr9_re_2_1 0 s2 x9_re_a1 0 -0.00010268486079439182
Gr9_im_2_1 0 s2 x9_im_a1 0 5.7237828857655e-05
Gr10_2_1 0 s2 x10_a1 0 2682278379.099439
Gr11_2_1 0 s2 x11_a1 0 -1852767830.533037
Gr12_2_1 0 s2 x12_a1 0 -799066519.2432361
Gr13_re_2_1 0 s2 x13_re_a1 0 0.0004965414429479107
Gr13_im_2_1 0 s2 x13_im_a1 0 0.00016731383595684554
Gr14_2_1 0 s2 x14_a1 0 2108306673.486467
Gr15_2_1 0 s2 x15_a1 0 -1681278520.763714
Gr16_re_2_1 0 s2 x16_re_a1 0 0.3191262376084948
Gr16_im_2_1 0 s2 x16_im_a1 0 -0.3307917299249794
Gr17_2_1 0 s2 x17_a1 0 81520591.03844175
Gr18_re_2_1 0 s2 x18_re_a1 0 6.53210414771711
Gr18_im_2_1 0 s2 x18_im_a1 0 11.608900214844537
Gr19_2_1 0 s2 x19_a1 0 299303348.3128662
Gr20_re_2_1 0 s2 x20_re_a1 0 -0.5167535978561497
Gr20_im_2_1 0 s2 x20_im_a1 0 -9.057446695918484
Gr21_re_2_1 0 s2 x21_re_a1 0 -50514763.7354806
Gr21_im_2_1 0 s2 x21_im_a1 0 -77113893.84164181
Gr22_re_2_1 0 s2 x22_re_a1 0 529348.5868858114
Gr22_im_2_1 0 s2 x22_im_a1 0 1080536.0208259341
Gr23_2_1 0 s2 x23_a1 0 -4704064.580412706
Gd2_2 0 s2 p2 0 0.01999177789874301
Fd2_2 0 s2 V2 0.9995888949371506
Gr1_2_2 0 s2 x1_a2 0 -238620565.21013218
Gr2_2_2 0 s2 x2_a2 0 12850959.631960388
Gr3_re_2_2 0 s2 x3_re_a2 0 4727802207.40609
Gr3_im_2_2 0 s2 x3_im_a2 0 52389753.81660905
Gr4_re_2_2 0 s2 x4_re_a2 0 1642294164.8074028
Gr4_im_2_2 0 s2 x4_im_a2 0 -1435127287.4053576
Gr5_re_2_2 0 s2 x5_re_a2 0 91553139.762743
Gr5_im_2_2 0 s2 x5_im_a2 0 -35008620.63076937
Gr6_re_2_2 0 s2 x6_re_a2 0 6096820184.328839
Gr6_im_2_2 0 s2 x6_im_a2 0 2089411499.6779819
Gr7_re_2_2 0 s2 x7_re_a2 0 8079325390.885713
Gr7_im_2_2 0 s2 x7_im_a2 0 -29894599796.88299
Gr8_re_2_2 0 s2 x8_re_a2 0 -4272876912.108438
Gr8_im_2_2 0 s2 x8_im_a2 0 -87186689079.65805
Gr9_re_2_2 0 s2 x9_re_a2 0 0.00010878012486938148
Gr9_im_2_2 0 s2 x9_im_a2 0 -0.00014014990934264687
Gr10_2_2 0 s2 x10_a2 0 -67293982996.931244
Gr11_2_2 0 s2 x11_a2 0 12130156681.07064
Gr12_2_2 0 s2 x12_a2 0 4413075333.728143
Gr13_re_2_2 0 s2 x13_re_a2 0 -0.0007852117319787809
Gr13_im_2_2 0 s2 x13_im_a2 0 0.00044560239175879844
Gr14_2_2 0 s2 x14_a2 0 -4689952681.189228
Gr15_2_2 0 s2 x15_a2 0 3099030305.2420564
Gr16_re_2_2 0 s2 x16_re_a2 0 0.0015339766831980763
Gr16_im_2_2 0 s2 x16_im_a2 0 0.518688028478796
Gr17_2_2 0 s2 x17_a2 0 -116768098.22128895
Gr18_re_2_2 0 s2 x18_re_a2 0 -12.641287925222516
Gr18_im_2_2 0 s2 x18_im_a2 0 -3.983389479929235
Gr19_2_2 0 s2 x19_a2 0 -366263150.7846249
Gr20_re_2_2 0 s2 x20_re_a2 0 5.963532835387456
Gr20_im_2_2 0 s2 x20_im_a2 0 4.675240516864016
Gr21_re_2_2 0 s2 x21_re_a2 0 50927697.62403442
Gr21_im_2_2 0 s2 x21_im_a2 0 61839450.935452856
Gr22_re_2_2 0 s2 x22_re_a2 0 -489404.6311613636
Gr22_im_2_2 0 s2 x22_im_a2 0 -563323.820065022
Gr23_2_2 0 s2 x23_a2 0 2650095.6969810147
*
* State networks driven by port 2
Cx1_a2 x1_a2 0 1.0
Gx1_a2 0 x1_a2 p2 0 0.07071067811865475
Fx1_a2 0 x1_a2 V2 3.5355339059327378
Rp1_a2 0 x1_a2 9.442076531440238e-13
Cx2_a2 x2_a2 0 1.0
Gx2_a2 0 x2_a2 p2 0 0.07071067811865475
Fx2_a2 0 x2_a2 V2 3.5355339059327378
Rp2_a2 0 x2_a2 8.119689655276655e-12
Cx3_re_a2 x3_re_a2 0 1.0
Gx3_re_a2 0 x3_re_a2 p2 0 0.1414213562373095
Fx3_re_a2 0 x3_re_a2 V2 7.0710678118654755
Rp3_re_re_a2 0 x3_re_a2 1.5798119894520322e-10
Gp3_re_im_a2 0 x3_re_a2 x3_im_a2 0 18767845883.733086
Cx3_im_a2 x3_im_a2 0 1.0
Gp3_im_re_a2 0 x3_im_a2 x3_re_a2 0 -18767845883.733086
Rp3_im_im_a2 0 x3_im_a2 1.5798119894520322e-10
Cx4_re_a2 x4_re_a2 0 1.0
Gx4_re_a2 0 x4_re_a2 p2 0 0.1414213562373095
Fx4_re_a2 0 x4_re_a2 V2 7.0710678118654755
Rp4_re_re_a2 0 x4_re_a2 1.7986273790456735e-10
Gp4_re_im_a2 0 x4_re_a2 x4_im_a2 0 13980092291.18969
Cx4_im_a2 x4_im_a2 0 1.0
Gp4_im_re_a2 0 x4_im_a2 x4_re_a2 0 -13980092291.18969
Rp4_im_im_a2 0 x4_im_a2 1.7986273790456735e-10
Cx5_re_a2 x5_re_a2 0 1.0
Gx5_re_a2 0 x5_re_a2 p2 0 0.1414213562373095
Fx5_re_a2 0 x5_re_a2 V2 7.0710678118654755
Rp5_re_re_a2 0 x5_re_a2 6.97718138849149e-11
Gp5_re_im_a2 0 x5_re_a2 x5_im_a2 0 5082871638.868746
Cx5_im_a2 x5_im_a2 0 1.0
Gp5_im_re_a2 0 x5_im_a2 x5_re_a2 0 -5082871638.868746
Rp5_im_im_a2 0 x5_im_a2 6.97718138849149e-11
Cx6_re_a2 x6_re_a2 0 1.0
Gx6_re_a2 0 x6_re_a2 p2 0 0.1414213562373095
Fx6_re_a2 0 x6_re_a2 V2 7.0710678118654755
Rp6_re_re_a2 0 x6_re_a2 1.2873579232108604e-10
Gp6_re_im_a2 0 x6_re_a2 x6_im_a2 0 10094502597.60111
Cx6_im_a2 x6_im_a2 0 1.0
Gp6_im_re_a2 0 x6_im_a2 x6_re_a2 0 -10094502597.60111
Rp6_im_im_a2 0 x6_im_a2 1.2873579232108604e-10
Cx7_re_a2 x7_re_a2 0 1.0
Gx7_re_a2 0 x7_re_a2 p2 0 0.1414213562373095
Fx7_re_a2 0 x7_re_a2 V2 7.0710678118654755
Rp7_re_re_a2 0 x7_re_a2 1.060466258107134e-10
Gp7_re_im_a2 0 x7_re_a2 x7_im_a2 0 7055729674.51677
Cx7_im_a2 x7_im_a2 0 1.0
Gp7_im_re_a2 0 x7_im_a2 x7_re_a2 0 -7055729674.51677
Rp7_im_im_a2 0 x7_im_a2 1.060466258107134e-10
Cx8_re_a2 x8_re_a2 0 1.0
Gx8_re_a2 0 x8_re_a2 p2 0 0.1414213562373095
Fx8_re_a2 0 x8_re_a2 V2 7.0710678118654755
Rp8_re_re_a2 0 x8_re_a2 1.2824551237449797e-10
Gp8_re_im_a2 0 x8_re_a2 x8_im_a2 0 1639001901.8720396
Cx8_im_a2 x8_im_a2 0 1.0
Gp8_im_re_a2 0 x8_im_a2 x8_re_a2 0 -1639001901.8720396
Rp8_im_im_a2 0 x8_im_a2 1.2824551237449797e-10
Cx9_re_a2 x9_re_a2 0 1.0
Gx9_re_a2 0 x9_re_a2 p2 0 0.1414213562373095
Fx9_re_a2 0 x9_re_a2 V2 7.0710678118654755
Rp9_re_re_a2 0 x9_re_a2 9.666847813637946e-10
Gp9_re_im_a2 0 x9_re_a2 x9_im_a2 0 5979089146.140133
Cx9_im_a2 x9_im_a2 0 1.0
Gp9_im_re_a2 0 x9_im_a2 x9_re_a2 0 -5979089146.140133
Rp9_im_im_a2 0 x9_im_a2 9.666847813637946e-10
Cx10_a2 x10_a2 0 1.0
Gx10_a2 0 x10_a2 p2 0 0.07071067811865475
Fx10_a2 0 x10_a2 V2 3.5355339059327378
Rp10_a2 0 x10_a2 1.782623803782255e-10
Cx11_a2 x11_a2 0 1.0
Gx11_a2 0 x11_a2 p2 0 0.07071067811865475
Fx11_a2 0 x11_a2 V2 3.5355339059327378
Rp11_a2 0 x11_a2 2.4338190879608553e-10
Cx12_a2 x12_a2 0 1.0
Gx12_a2 0 x12_a2 p2 0 0.07071067811865475
Fx12_a2 0 x12_a2 V2 3.5355339059327378
Rp12_a2 0 x12_a2 2.5897002726286557e-10
Cx13_re_a2 x13_re_a2 0 1.0
Gx13_re_a2 0 x13_re_a2 p2 0 0.1414213562373095
Fx13_re_a2 0 x13_re_a2 V2 7.0710678118654755
Rp13_re_re_a2 0 x13_re_a2 1.8162817414561346e-09
Gp13_re_im_a2 0 x13_re_a2 x13_im_a2 0 2497837479.278144
Cx13_im_a2 x13_im_a2 0 1.0
Gp13_im_re_a2 0 x13_im_a2 x13_re_a2 0 -2497837479.278144
Rp13_im_im_a2 0 x13_im_a2 1.8162817414561346e-09
Cx14_a2 x14_a2 0 1.0
Gx14_a2 0 x14_a2 p2 0 0.07071067811865475
Fx14_a2 0 x14_a2 V2 3.5355339059327378
Rp14_a2 0 x14_a2 4.4993091661383564e-10
Cx15_a2 x15_a2 0 1.0
Gx15_a2 0 x15_a2 p2 0 0.07071067811865475
Fx15_a2 0 x15_a2 V2 3.5355339059327378
Rp15_a2 0 x15_a2 5.450887754769265e-10
Cx16_re_a2 x16_re_a2 0 1.0
Gx16_re_a2 0 x16_re_a2 p2 0 0.1414213562373095
Fx16_re_a2 0 x16_re_a2 V2 7.0710678118654755
Rp16_re_re_a2 0 x16_re_a2 5.151942745762834e-09
Gp16_re_im_a2 0 x16_re_a2 x16_im_a2 0 1093458614.9636781
Cx16_im_a2 x16_im_a2 0 1.0
Gp16_im_re_a2 0 x16_im_a2 x16_re_a2 0 -1093458614.9636781
Rp16_im_im_a2 0 x16_im_a2 5.151942745762834e-09
Cx17_a2 x17_a2 0 1.0
Gx17_a2 0 x17_a2 p2 0 0.07071067811865475
Fx17_a2 0 x17_a2 V2 3.5355339059327378
Rp17_a2 0 x17_a2 7.468174905395952e-10
Cx18_re_a2 x18_re_a2 0 1.0
Gx18_re_a2 0 x18_re_a2 p2 0 0.1414213562373095
Fx18_re_a2 0 x18_re_a2 V2 7.0710678118654755
Rp18_re_re_a2 0 x18_re_a2 5.801413313943193e-09
Gp18_re_im_a2 0 x18_re_a2 x18_im_a2 0 801740987.1040207
Cx18_im_a2 x18_im_a2 0 1.0
Gp18_im_re_a2 0 x18_im_a2 x18_re_a2 0 -801740987.1040207
Rp18_im_im_a2 0 x18_im_a2 5.801413313943193e-09
Cx19_a2 x19_a2 0 1.0
Gx19_a2 0 x19_a2 p2 0 0.07071067811865475
Fx19_a2 0 x19_a2 V2 3.5355339059327378
Rp19_a2 0 x19_a2 9.34521390895619e-10
Cx20_re_a2 x20_re_a2 0 1.0
Gx20_re_a2 0 x20_re_a2 p2 0 0.1414213562373095
Fx20_re_a2 0 x20_re_a2 V2 7.0710678118654755
Rp20_re_re_a2 0 x20_re_a2 2.5104948968726765e-08
Gp20_re_im_a2 0 x20_re_a2 x20_im_a2 0 563429512.1737212
Cx20_im_a2 x20_im_a2 0 1.0
Gp20_im_re_a2 0 x20_im_a2 x20_re_a2 0 -563429512.1737212
Rp20_im_im_a2 0 x20_im_a2 2.5104948968726765e-08
Cx21_re_a2 x21_re_a2 0 1.0
Gx21_re_a2 0 x21_re_a2 p2 0 0.1414213562373095
Fx21_re_a2 0 x21_re_a2 V2 7.0710678118654755
Rp21_re_re_a2 0 x21_re_a2 1.6655982964260597e-09
Gp21_re_im_a2 0 x21_re_a2 x21_im_a2 0 112285982.4827143
Cx21_im_a2 x21_im_a2 0 1.0
Gp21_im_re_a2 0 x21_im_a2 x21_re_a2 0 -112285982.4827143
Rp21_im_im_a2 0 x21_im_a2 1.6655982964260597e-09
Cx22_re_a2 x22_re_a2 0 1.0
Gx22_re_a2 0 x22_re_a2 p2 0 0.1414213562373095
Fx22_re_a2 0 x22_re_a2 V2 7.0710678118654755
Rp22_re_re_a2 0 x22_re_a2 3.2724352090476573e-09
Gp22_re_im_a2 0 x22_re_a2 x22_im_a2 0 153024970.97965515
Cx22_im_a2 x22_im_a2 0 1.0
Gp22_im_re_a2 0 x22_im_a2 x22_re_a2 0 -153024970.97965515
Rp22_im_im_a2 0 x22_im_a2 3.2724352090476573e-09
Cx23_a2 x23_a2 0 1.0
Gx23_a2 0 x23_a2 p2 0 0.07071067811865475
Fx23_a2 0 x23_a2 V2 3.5355339059327378
Rp23_a2 0 x23_a2 3.519195694355655e-09
.ENDS s_equivalent
