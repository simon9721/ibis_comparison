* Phase-1 direct-load PRBS7 ngspice
.title inv_chain PRBS7 UI=0.5ns InputDrivenHybridV2StateInitializedReplay
.temp 27
.options method=trap reltol=1e-3 abstol=1e-9 vntol=1e-5 gmin=1e-10 trtol=10 itl4=100

Vin in_dig 0 PWL(
+ 0n 0
+ 5n 0
+ 5.05n 1.8
+ 8.5n 1.8
+ 8.55n 0
+ 11.5n 0
+ 11.55n 1.8
+ 12n 1.8
+ 12.05n 0
+ 14.5n 0
+ 14.55n 1.8
+ 15.5n 1.8
+ 15.55n 0
+ 17.5n 0
+ 17.55n 1.8
+ 18n 1.8
+ 18.05n 0
+ 18.5n 0
+ 18.55n 1.8
+ 19n 1.8
+ 19.05n 0
+ 20.5n 0
+ 20.55n 1.8
+ 22.5n 1.8
+ 22.55n 0
+ 23.5n 0
+ 23.55n 1.8
+ 24n 1.8
+ 24.05n 0
+ 25.5n 0
+ 25.55n 1.8
+ 26n 1.8
+ 26.05n 0
+ 26.5n 0
+ 26.55n 1.8
+ 27.5n 1.8
+ 27.55n 0
+ 28.5n 0
+ 28.55n 1.8
+ 30n 1.8
+ 30.05n 0
+ 30.5n 0
+ 30.55n 1.8
+ 31n 1.8
+ 31.05n 0
+ 31.5n 0
+ 31.55n 1.8
+ 32n 1.8
+ 32.05n 0
+ 33n 0
+ 33.05n 1.8
+ 35.5n 1.8
+ 35.55n 0
+ 36n 0
+ 36.05n 1.8
+ 36.5n 1.8
+ 36.55n 0
+ 38.5n 0
+ 38.55n 1.8
+ 40n 1.8
+ 40.05n 0
+ 41.5n 0
+ 41.55n 1.8
+ 42n 1.8
+ 42.05n 0
+ 43n 0
+ 43.05n 1.8
+ 43.5n 1.8
+ 43.55n 0
+ 44.5n 0
+ 44.55n 1.8
+ 45.5n 1.8
+ 45.55n 0
+ 46n 0
+ 46.05n 1.8
+ 47n 1.8
+ 47.05n 0
+ 47.5n 0
+ 47.55n 1.8
+ 48n 1.8
+ 48.05n 0
+ 48.5n 0
+ 48.55n 1.8
+ 49.5n 1.8
+ 49.55n 0
+ 50n 0
+ 50.05n 1.8
+ 52n 1.8
+ 52.05n 0
+ 52.5n 0
+ 52.55n 1.8
+ 53.5n 1.8
+ 53.55n 0
+ 55n 0
+ 55.05n 1.8
+ 56n 1.8
+ 56.05n 0
+ 56.5n 0
+ 56.55n 1.8
+ 57n 1.8
+ 57.05n 0
+ 58n 0
+ 58.05n 1.8
+ 58.5n 1.8
+ 58.55n 0
+ 59n 0
+ 59.05n 1.8
+ 60.5n 1.8
+ 60.55n 0
+ 61n 0
+ 61.05n 1.8
+ 62.5n 1.8
+ 62.55n 0
+ 63.5n 0
+ 63.55n 1.8
+ 64.5n 1.8
+ 64.55n 0
+ 65.5n 0
+ 65.55n 1.8
+ 66n 1.8
+ 66.05n 0
+ 66.5n 0
+ 66.55n 1.8
+ 67n 1.8
+ 67.05n 0
+ 67.5n 0
+ 67.55n 1.8
+ 68n 1.8
+ 68.05n 0
+ 68.5n 0
+ 68.55n 1.8
+ 72n 1.8
+ 72.05n 0
+ 75n 0
+ 75.05n 1.8
+ 75.5n 1.8
+ 75.55n 0
+ 78n 0
+ 78.05n 1.8
+ 79n 1.8
+ 79.05n 0
+ 81n 0
+ 81.05n 1.8
+ 81.5n 1.8
+ 81.55n 0
+ 82n 0
+ 82.05n 1.8
+ 82.5n 1.8
+ 82.55n 0
+ 84n 0
+ 84.05n 1.8
+ 86n 1.8
+ 86.05n 0
+ 87n 0
+ 87.05n 1.8
+ 87.5n 1.8
+ 87.55n 0
+ 89n 0
+ 89.05n 1.8
+ 89.5n 1.8
+ 89.55n 0
+ 90n 0
+ 90.05n 1.8
+ 91n 1.8
+ 91.05n 0
+ 92n 0
+ 92.05n 1.8
+ 93.5n 1.8
+ 93.55n 0
+ 94n 0
+ 94.05n 1.8
+ 94.5n 1.8
+ 94.55n 0
+ 95n 0
+ 95.05n 1.8
+ 95.5n 1.8
+ 95.55n 0
+ 96.5n 0
+ 96.55n 1.8
+ 99n 1.8
+ 99.05n 0
+ 99.5n 0
+ 99.55n 1.8
+ 100n 1.8
+ 100.05n 0
+ 102n 0
+ 102.05n 1.8
+ 103.5n 1.8
+ 103.55n 0
+ 105n 0
+ 105.05n 1.8
+ 105.5n 1.8
+ 105.55n 0
+ 106.5n 0
+ 106.55n 1.8
+ 107n 1.8
+ 107.05n 0
+ 108n 0
+ 108.05n 1.8
+ 109n 1.8
+ 109.05n 0
+ 109.5n 0
+ 109.55n 1.8
+ 110.5n 1.8
+ 110.55n 0
+ 111n 0
+ 111.05n 1.8
+ 111.5n 1.8
+ 111.55n 0
+ 112n 0
+ 112.05n 1.8
+ 113n 1.8
+ 113.05n 0
+ 113.5n 0
+ 113.55n 1.8
+ 115.5n 1.8
+ 115.55n 0
+ 116n 0
+ 116.05n 1.8
+ 117n 1.8
+ 117.05n 0
+ 118.5n 0
+ 118.55n 1.8
+ 119.5n 1.8
+ 119.55n 0
+ 120n 0
+ 120.05n 1.8
+ 120.5n 1.8
+ 120.55n 0
+ 121.5n 0
+ 121.55n 1.8
+ 122n 1.8
+ 122.05n 0
+ 122.5n 0
+ 122.55n 1.8
+ 124n 1.8
+ 124.05n 0
+ 124.5n 0
+ 124.55n 1.8
+ 126n 1.8
+ 126.05n 0
+ 127n 0
+ 127.05n 1.8
+ 128n 1.8
+ 128.05n 0
+ 129n 0
+ 129.05n 1.8
+ 129.5n 1.8
+ 129.55n 0
+ 130n 0
+ 130.05n 1.8
+ 130.5n 1.8
+ 130.55n 0
+ 131n 0
+ 131.05n 1.8
+ 131.5n 1.8
+ 131.55n 0
+ 132n 0
+ 140n 0 )

Ven en_sig 0 DC 1.8
Vdd vdd 0 DC 1.8
.include 'driver2_OutputInput_Typical.sub'
XDRV pad in_dig en_sig vdd 0 driver2_OutputInput_Typical
Rload pad 0 50
Cload pad 0 2p

.save V(in_dig) V(pad) V(xdrv.ku) V(xdrv.kd) V(xdrv.gup) V(xdrv.gdn) V(xdrv.guptarget) V(xdrv.gdntarget) V(xdrv.kugate) V(xdrv.kdgate) V(xdrv.kuleg) V(xdrv.kdleg) V(xdrv.kutarget) V(xdrv.kdtarget) V(xdrv.hfall_after_rise) V(xdrv.hrise_after_fall) V(xdrv.hreverseraw) V(xdrv.hsettled) V(xdrv.hhybridactive) V(xdrv.hhybridv2active) V(xdrv.v2kusamp) V(xdrv.v2kdsamp) V(xdrv.v2elapsed) V(xdrv.v2kuprogress) V(xdrv.v2kdprogress) V(xdrv.v2kureplay) V(xdrv.v2kdreplay) V(xdrv.v2starterrku) V(xdrv.v2starterrkd) V(xdrv.v2sample)
.tran 0.005n 25.5n

.control
set filetype=binary
run
linearize
write run.raw V(in_dig) V(pad) V(xdrv.ku) V(xdrv.kd) V(xdrv.gup) V(xdrv.gdn) V(xdrv.guptarget) V(xdrv.gdntarget) V(xdrv.kugate) V(xdrv.kdgate) V(xdrv.kuleg) V(xdrv.kdleg) V(xdrv.kutarget) V(xdrv.kdtarget) V(xdrv.hfall_after_rise) V(xdrv.hrise_after_fall) V(xdrv.hreverseraw) V(xdrv.hsettled) V(xdrv.hhybridactive) V(xdrv.hhybridv2active) V(xdrv.v2kusamp) V(xdrv.v2kdsamp) V(xdrv.v2elapsed) V(xdrv.v2kuprogress) V(xdrv.v2kdprogress) V(xdrv.v2kureplay) V(xdrv.v2kdreplay) V(xdrv.v2starterrku) V(xdrv.v2starterrkd) V(xdrv.v2sample)
quit
.endc
.end
