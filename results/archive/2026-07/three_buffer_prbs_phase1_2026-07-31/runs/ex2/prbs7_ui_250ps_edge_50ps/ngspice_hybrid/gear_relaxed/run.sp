* Phase-1 direct-load PRBS7 ngspice
.title ex2 PRBS7 UI=0.25ns InputDrivenTwoStateGateDirectionalDualResidualHybrid
.temp 27
.options method=gear maxord=2 reltol=1e-3 abstol=1e-9 vntol=1e-5 gmin=1e-10 trtol=10 itl4=100

Vin in_dig 0 PWL(
+ 0n 0
+ 5n 0
+ 5.05n 3.3
+ 6.75n 3.3
+ 6.8n 0
+ 8.25n 0
+ 8.3n 3.3
+ 8.5n 3.3
+ 8.55n 0
+ 9.75n 0
+ 9.8n 3.3
+ 10.25n 3.3
+ 10.3n 0
+ 11.25n 0
+ 11.3n 3.3
+ 11.5n 3.3
+ 11.55n 0
+ 11.75n 0
+ 11.8n 3.3
+ 12n 3.3
+ 12.05n 0
+ 12.75n 0
+ 12.8n 3.3
+ 13.75n 3.3
+ 13.8n 0
+ 14.25n 0
+ 14.3n 3.3
+ 14.5n 3.3
+ 14.55n 0
+ 15.25n 0
+ 15.3n 3.3
+ 15.5n 3.3
+ 15.55n 0
+ 15.75n 0
+ 15.8n 3.3
+ 16.25n 3.3
+ 16.3n 0
+ 16.75n 0
+ 16.8n 3.3
+ 17.5n 3.3
+ 17.55n 0
+ 17.75n 0
+ 17.8n 3.3
+ 18n 3.3
+ 18.05n 0
+ 18.25n 0
+ 18.3n 3.3
+ 18.5n 3.3
+ 18.55n 0
+ 19n 0
+ 19.05n 3.3
+ 20.25n 3.3
+ 20.3n 0
+ 20.5n 0
+ 20.55n 3.3
+ 20.75n 3.3
+ 20.8n 0
+ 21.75n 0
+ 21.8n 3.3
+ 22.5n 3.3
+ 22.55n 0
+ 23.25n 0
+ 23.3n 3.3
+ 23.5n 3.3
+ 23.55n 0
+ 24n 0
+ 24.05n 3.3
+ 24.25n 3.3
+ 24.3n 0
+ 24.75n 0
+ 24.8n 3.3
+ 25.25n 3.3
+ 25.3n 0
+ 25.5n 0
+ 25.55n 3.3
+ 26n 3.3
+ 26.05n 0
+ 26.25n 0
+ 26.3n 3.3
+ 26.5n 3.3
+ 26.55n 0
+ 26.75n 0
+ 26.8n 3.3
+ 27.25n 3.3
+ 27.3n 0
+ 27.5n 0
+ 27.55n 3.3
+ 28.5n 3.3
+ 28.55n 0
+ 28.75n 0
+ 28.8n 3.3
+ 29.25n 3.3
+ 29.3n 0
+ 30n 0
+ 30.05n 3.3
+ 30.5n 3.3
+ 30.55n 0
+ 30.75n 0
+ 30.8n 3.3
+ 31n 3.3
+ 31.05n 0
+ 31.5n 0
+ 31.55n 3.3
+ 31.75n 3.3
+ 31.8n 0
+ 32n 0
+ 32.05n 3.3
+ 32.75n 3.3
+ 32.8n 0
+ 33n 0
+ 33.05n 3.3
+ 33.75n 3.3
+ 33.8n 0
+ 34.25n 0
+ 34.3n 3.3
+ 34.75n 3.3
+ 34.8n 0
+ 35.25n 0
+ 35.3n 3.3
+ 35.5n 3.3
+ 35.55n 0
+ 35.75n 0
+ 35.8n 3.3
+ 36n 3.3
+ 36.05n 0
+ 36.25n 0
+ 36.3n 3.3
+ 36.5n 3.3
+ 36.55n 0
+ 36.75n 0
+ 36.8n 3.3
+ 38.5n 3.3
+ 38.55n 0
+ 40n 0
+ 40.05n 3.3
+ 40.25n 3.3
+ 40.3n 0
+ 41.5n 0
+ 41.55n 3.3
+ 42n 3.3
+ 42.05n 0
+ 43n 0
+ 43.05n 3.3
+ 43.25n 3.3
+ 43.3n 0
+ 43.5n 0
+ 43.55n 3.3
+ 43.75n 3.3
+ 43.8n 0
+ 44.5n 0
+ 44.55n 3.3
+ 45.5n 3.3
+ 45.55n 0
+ 46n 0
+ 46.05n 3.3
+ 46.25n 3.3
+ 46.3n 0
+ 47n 0
+ 47.05n 3.3
+ 47.25n 3.3
+ 47.3n 0
+ 47.5n 0
+ 47.55n 3.3
+ 48n 3.3
+ 48.05n 0
+ 48.5n 0
+ 48.55n 3.3
+ 49.25n 3.3
+ 49.3n 0
+ 49.5n 0
+ 49.55n 3.3
+ 49.75n 3.3
+ 49.8n 0
+ 50n 0
+ 50.05n 3.3
+ 50.25n 3.3
+ 50.3n 0
+ 50.75n 0
+ 50.8n 3.3
+ 52n 3.3
+ 52.05n 0
+ 52.25n 0
+ 52.3n 3.3
+ 52.5n 3.3
+ 52.55n 0
+ 53.5n 0
+ 53.55n 3.3
+ 54.25n 3.3
+ 54.3n 0
+ 55n 0
+ 55.05n 3.3
+ 55.25n 3.3
+ 55.3n 0
+ 55.75n 0
+ 55.8n 3.3
+ 56n 3.3
+ 56.05n 0
+ 56.5n 0
+ 56.55n 3.3
+ 57n 3.3
+ 57.05n 0
+ 57.25n 0
+ 57.3n 3.3
+ 57.75n 3.3
+ 57.8n 0
+ 58n 0
+ 58.05n 3.3
+ 58.25n 3.3
+ 58.3n 0
+ 58.5n 0
+ 58.55n 3.3
+ 59n 3.3
+ 59.05n 0
+ 59.25n 0
+ 59.3n 3.3
+ 60.25n 3.3
+ 60.3n 0
+ 60.5n 0
+ 60.55n 3.3
+ 61n 3.3
+ 61.05n 0
+ 61.75n 0
+ 61.8n 3.3
+ 62.25n 3.3
+ 62.3n 0
+ 62.5n 0
+ 62.55n 3.3
+ 62.75n 3.3
+ 62.8n 0
+ 63.25n 0
+ 63.3n 3.3
+ 63.5n 3.3
+ 63.55n 0
+ 63.75n 0
+ 63.8n 3.3
+ 64.5n 3.3
+ 64.55n 0
+ 64.75n 0
+ 64.8n 3.3
+ 65.5n 3.3
+ 65.55n 0
+ 66n 0
+ 66.05n 3.3
+ 66.5n 3.3
+ 66.55n 0
+ 67n 0
+ 67.05n 3.3
+ 67.25n 3.3
+ 67.3n 0
+ 67.5n 0
+ 67.55n 3.3
+ 67.75n 3.3
+ 67.8n 0
+ 68n 0
+ 68.05n 3.3
+ 68.25n 3.3
+ 68.3n 0
+ 68.5n 0
+ 76.5n 0 )

Ven en_sig 0 DC 0
Vdd vdd 0 DC 3.3
.include 'driver_OutputInput_Typical.sub'
XDRV pad in_dig en_sig vdd 0 driver_OutputInput_Typical
Rload pad 0 50
Cload pad 0 2p

.save V(in_dig) V(pad) V(xdrv.ku) V(xdrv.kd) V(xdrv.gup) V(xdrv.gdn) V(xdrv.guptarget) V(xdrv.gdntarget) V(xdrv.kugate) V(xdrv.kdgate) V(xdrv.kuleg) V(xdrv.kdleg) V(xdrv.kutarget) V(xdrv.kdtarget) V(xdrv.hfall_after_rise) V(xdrv.hrise_after_fall) V(xdrv.hreverseraw) V(xdrv.hsettled) V(xdrv.hhybridactive)
.tran 0.005n 17.75n

.control
set filetype=binary
run
linearize
write run.raw V(in_dig) V(pad) V(xdrv.ku) V(xdrv.kd) V(xdrv.gup) V(xdrv.gdn) V(xdrv.guptarget) V(xdrv.gdntarget) V(xdrv.kugate) V(xdrv.kdgate) V(xdrv.kuleg) V(xdrv.kdleg) V(xdrv.kutarget) V(xdrv.kdtarget) V(xdrv.hfall_after_rise) V(xdrv.hrise_after_fall) V(xdrv.hreverseraw) V(xdrv.hsettled) V(xdrv.hhybridactive)
quit
.endc
.end
