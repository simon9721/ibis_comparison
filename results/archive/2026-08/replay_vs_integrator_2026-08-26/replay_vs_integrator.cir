* Replay against integrator: same command, same map, same pad.
.param C_pkg=0 L_pkg=0 R_pkg=0 C_comp=1.2e-12
VVCC VCC 0 3.3
VVSS VSS 0 0
VGUPT GUPTARGET 0 PWL(0.000000n 0 5.992481n 0 5.992581n 1 7.293500n 1 7.293600n 0 14.000000n 0)
VGDNT GDNTARGET 0 PWL(0.000000n 1 5.850079n 1 5.850179n 0 9.057136n 0 9.057236n 1 14.000000n 1)
BGUPA GUPA 0 I = -1p * (V(GUPTARGET) - V(GUPA)) / ((V(GUPTARGET) > V(GUPA)) ? 1.12476722n : 0.112212769n)
CGUPA GUPA 0 1p ic=0
RGUPA GUPA 0 1e12
BGDNA GDNA 0 I = -1p * (V(GDNTARGET) - V(GDNA)) / ((V(GDNTARGET) > V(GDNA)) ? 0.271301632n : 0.244985656n)
CGDNA GDNA 0 1p ic=1
BGDNABASE GDNABASE 0 V = 1.0
RGDNA GDNA GDNABASE 1e12
VGUPB GUPB 0 PWL(0.000000n 0 0.002000n 0 0.004000n 0 0.006000n 0 0.008000n 0 0.010000n 0 0.012000n 0 0.014000n 0 0.016000n 0 0.018000n 0 0.020000n 0 0.022000n 0 0.024000n 0 0.026000n 0 0.028000n 0 0.030000n 0 0.032000n 0 0.034000n 0 0.036000n 0 0.038000n 0 0.040000n 0 0.042000n 0 0.044000n 0 0.046000n 0 0.048000n 0 0.050000n 0 0.052000n 0 0.054000n 0 0.056000n 0 0.058000n 0 0.060000n 0 0.062000n 0 0.064000n 0 0.066000n 0 0.068000n 0 0.070000n 0 0.072000n 0 0.074000n 0 0.076000n 0 0.078000n 0 0.080000n 0 0.082000n 0 0.084000n 0 0.086000n 0 0.088000n 0 0.090000n 0 0.092000n 0 0.094000n 0 0.096000n 0 0.098000n 0 0.100000n 0 0.102000n 0 0.104000n 0 0.106000n 0 0.108000n 0 0.110000n 0 0.112000n 0 0.114000n 0 0.116000n 0 0.118000n 0 0.120000n 0 0.122000n 0 0.124000n 0 0.126000n 0 0.128000n 0 0.130000n 0 0.132000n 0 0.134000n 0 0.136000n 0 0.138000n 0 0.140000n 0 0.142000n 0 0.144000n 0 0.146000n 0 0.148000n 0 0.150000n 0 0.152000n 0 0.154000n 0 0.156000n 0 0.158000n 0 0.160000n 0 0.162000n 0 0.164000n 0 0.166000n 0 0.168000n 0 0.170000n 0 0.172000n 0 0.174000n 0 0.176000n 0 0.178000n 0 0.180000n 0 0.182000n 0 0.184000n 0 0.186000n 0 0.188000n 0 0.190000n 0 0.192000n 0 0.194000n 0 0.196000n 0 0.198000n 0 0.200000n 0 0.202000n 0 0.204000n 0 0.206000n 0 0.208000n 0 0.210000n 0 0.212000n 0 0.214000n 0 0.216000n 0 0.218000n 0 0.220000n 0 0.222000n 0 0.224000n 0 0.226000n 0 0.228000n 0 0.230000n 0 0.232000n 0 0.234000n 0 0.236000n 0 0.238000n 0 0.240000n 0 0.242000n 0 0.244000n 0 0.246000n 0 0.248000n 0 0.250000n 0 0.252000n 0 0.254000n 0 0.256000n 0 0.258000n 0 0.260000n 0 0.262000n 0 0.264000n 0 0.266000n 0 0.268000n 0 0.270000n 0 0.272000n 0 0.274000n 0 0.276000n 0 0.278000n 0 0.280000n 0 0.282000n 0 0.284000n 0 0.286000n 0 0.288000n 0 0.290000n 0 0.292000n 0 0.294000n 0 0.296000n 0 0.298000n 0 0.300000n 0 0.302000n 0 0.304000n 0 0.306000n 0 0.308000n 0 0.310000n 0 0.312000n 0 0.314000n 0 0.316000n 0 0.318000n 0 0.320000n 0 0.322000n 0 0.324000n 0 0.326000n 0 0.328000n 0 0.330000n 0 0.332000n 0 0.334000n 0 0.336000n 0 0.338000n 0 0.340000n 0 0.342000n 0 0.344000n 0 0.346000n 0 0.348000n 0 0.350000n 0 0.352000n 0 0.354000n 0 0.356000n 0 0.358000n 0 0.360000n 0 0.362000n 0 0.364000n 0 0.366000n 0 0.368000n 0 0.370000n 0 0.372000n 0 0.374000n 0 0.376000n 0 0.378000n 0 0.380000n 0 0.382000n 0 0.384000n 0 0.386000n 0 0.388000n 0 0.390000n 0 0.392000n 0 0.394000n 0 0.396000n 0 0.398000n 0 0.400000n 0 0.402000n 0 0.404000n 0 0.406000n 0 0.408000n 0 0.410000n 0 0.412000n 0 0.414000n 0 0.416000n 0 0.418000n 0 0.420000n 0 0.422000n 0 0.424000n 0 0.426000n 0 0.428000n 0 0.430000n 0 0.432000n 0 0.434000n 0 0.436000n 0 0.438000n 0 0.440000n 0 0.442000n 0 0.444000n 0 0.446000n 0 0.448000n 0 0.450000n 0 0.452000n 0 0.454000n 0 0.456000n 0 0.458000n 0 0.460000n 0 0.462000n 0 0.464000n 0 0.466000n 0 0.468000n 0 0.470000n 0 0.472000n 0 0.474000n 0 0.476000n 0 0.478000n 0 0.480000n 0 0.482000n 0 0.484000n 0 0.486000n 0 0.488000n 0 0.490000n 0 0.492000n 0 0.494000n 0 0.496000n 0 0.498000n 0 0.500000n 0 0.502000n 0 0.504000n 0 0.506000n 0 0.508000n 0 0.510000n 0 0.512000n 0 0.514000n 0 0.516000n 0 0.518000n 0 0.520000n 0 0.522000n 0 0.524000n 0 0.526000n 0 0.528000n 0 0.530000n 0 0.532000n 0 0.534000n 0 0.536000n 0 0.538000n 0 0.540000n 0 0.542000n 0 0.544000n 0 0.546000n 0 0.548000n 0 0.550000n 0 0.552000n 0 0.554000n 0 0.556000n 0 0.558000n 0 0.560000n 0 0.562000n 0 0.564000n 0 0.566000n 0 0.568000n 0 0.570000n 0 0.572000n 0 0.574000n 0 0.576000n 0 0.578000n 0 0.580000n 0 0.582000n 0 0.584000n 0 0.586000n 0 0.588000n 0 0.590000n 0 0.592000n 0 0.594000n 0 0.596000n 0 0.598000n 0 0.600000n 0 0.602000n 0 0.604000n 0 0.606000n 0 0.608000n 0 0.610000n 0 0.612000n 0 0.614000n 0 0.616000n 0 0.618000n 0 0.620000n 0 0.622000n 0 0.624000n 0 0.626000n 0 0.628000n 0 0.630000n 0 0.632000n 0 0.634000n 0 0.636000n 0 0.638000n 0 0.640000n 0 0.642000n 0 0.644000n 0 0.646000n 0 0.648000n 0 0.650000n 0 0.652000n 0 0.654000n 0 0.656000n 0 0.658000n 0 0.660000n 0 0.662000n 0 0.664000n 0 0.666000n 0 0.668000n 0 0.670000n 0 0.672000n 0 0.674000n 0 0.676000n 0 0.678000n 0 0.680000n 0 0.682000n 0 0.684000n 0 0.686000n 0 0.688000n 0 0.690000n 0 0.692000n 0 0.694000n 0 0.696000n 0 0.698000n 0 0.700000n 0 0.702000n 0 0.704000n 0 0.706000n 0 0.708000n 0 0.710000n 0 0.712000n 0 0.714000n 0 0.716000n 0 0.718000n 0 0.720000n 0 0.722000n 0 0.724000n 0 0.726000n 0 0.728000n 0 0.730000n 0 0.732000n 0 0.734000n 0 0.736000n 0 0.738000n 0 0.740000n 0 0.742000n 0 0.744000n 0 0.746000n 0 0.748000n 0 0.750000n 0 0.752000n 0 0.754000n 0 0.756000n 0 0.758000n 0 0.760000n 0 0.762000n 0 0.764000n 0 0.766000n 0 0.768000n 0 0.770000n 0 0.772000n 0 0.774000n 0 0.776000n 0 0.778000n 0 0.780000n 0 0.782000n 0 0.784000n 0 0.786000n 0 0.788000n 0 0.790000n 0 0.792000n 0 0.794000n 0 0.796000n 0 0.798000n 0 0.800000n 0 0.802000n 0 0.804000n 0 0.806000n 0 0.808000n 0 0.810000n 0 0.812000n 0 0.814000n 0 0.816000n 0 0.818000n 0 0.820000n 0 0.822000n 0 0.824000n 0 0.826000n 0 0.828000n 0 0.830000n 0 0.832000n 0 0.834000n 0 0.836000n 0 0.838000n 0 0.840000n 0 0.842000n 0 0.844000n 0 0.846000n 0 0.848000n 0 0.850000n 0 0.852000n 0 0.854000n 0 0.856000n 0 0.858000n 0 0.860000n 0 0.862000n 0 0.864000n 0 0.866000n 0 0.868000n 0 0.870000n 0 0.872000n 0 0.874000n 0 0.876000n 0 0.878000n 0 0.880000n 0 0.882000n 0 0.884000n 0 0.886000n 0 0.888000n 0 0.890000n 0 0.892000n 0 0.894000n 0 0.896000n 0 0.898000n 0 0.900000n 0 0.902000n 0 0.904000n 0 0.906000n 0 0.908000n 0 0.910000n 0 0.912000n 0 0.914000n 0 0.916000n 0 0.918000n 0 0.920000n 0 0.922000n 0 0.924000n 0 0.926000n 0 0.928000n 0 0.930000n 0 0.932000n 0 0.934000n 0 0.936000n 0 0.938000n 0 0.940000n 0 0.942000n 0 0.944000n 0 0.946000n 0 0.948000n 0 0.950000n 0 0.952000n 0 0.954000n 0 0.956000n 0 0.958000n 0 0.960000n 0 0.962000n 0 0.964000n 0 0.966000n 0 0.968000n 0 0.970000n 0 0.972000n 0 0.974000n 0 0.976000n 0 0.978000n 0 0.980000n 0 0.982000n 0 0.984000n 0 0.986000n 0 0.988000n 0 0.990000n 0 0.992000n 0 0.994000n 0 0.996000n 0 0.998000n 0 1.000000n 0 1.002000n 0 1.004000n 0 1.006000n 0 1.008000n 0 1.010000n 0 1.012000n 0 1.014000n 0 1.016000n 0 1.018000n 0 1.020000n 0 1.022000n 0 1.024000n 0 1.026000n 0 1.028000n 0 1.030000n 0 1.032000n 0 1.034000n 0 1.036000n 0 1.038000n 0 1.040000n 0 1.042000n 0 1.044000n 0 1.046000n 0 1.048000n 0 1.050000n 0 1.052000n 0 1.054000n 0 1.056000n 0 1.058000n 0 1.060000n 0 1.062000n 0 1.064000n 0 1.066000n 0 1.068000n 0 1.070000n 0 1.072000n 0 1.074000n 0 1.076000n 0 1.078000n 0 1.080000n 0 1.082000n 0 1.084000n 0 1.086000n 0 1.088000n 0 1.090000n 0 1.092000n 0 1.094000n 0 1.096000n 0 1.098000n 0 1.100000n 0 1.102000n 0 1.104000n 0 1.106000n 0 1.108000n 0 1.110000n 0 1.112000n 0 1.114000n 0 1.116000n 0 1.118000n 0 1.120000n 0 1.122000n 0 1.124000n 0 1.126000n 0 1.128000n 0 1.130000n 0 1.132000n 0 1.134000n 0 1.136000n 0 1.138000n 0 1.140000n 0 1.142000n 0 1.144000n 0 1.146000n 0 1.148000n 0 1.150000n 0 1.152000n 0 1.154000n 0 1.156000n 0 1.158000n 0 1.160000n 0 1.162000n 0 1.164000n 0 1.166000n 0 1.168000n 0 1.170000n 0 1.172000n 0 1.174000n 0 1.176000n 0 1.178000n 0 1.180000n 0 1.182000n 0 1.184000n 0 1.186000n 0 1.188000n 0 1.190000n 0 1.192000n 0 1.194000n 0 1.196000n 0 1.198000n 0 1.200000n 0 1.202000n 0 1.204000n 0 1.206000n 0 1.208000n 0 1.210000n 0 1.212000n 0 1.214000n 0 1.216000n 0 1.218000n 0 1.220000n 0 1.222000n 0 1.224000n 0 1.226000n 0 1.228000n 0 1.230000n 0 1.232000n 0 1.234000n 0 1.236000n 0 1.238000n 0 1.240000n 0 1.242000n 0 1.244000n 0 1.246000n 0 1.248000n 0 1.250000n 0 1.252000n 0 1.254000n 0 1.256000n 0 1.258000n 0 1.260000n 0 1.262000n 0 1.264000n 0 1.266000n 0 1.268000n 0 1.270000n 0 1.272000n 0 1.274000n 0 1.276000n 0 1.278000n 0 1.280000n 0 1.282000n 0 1.284000n 0 1.286000n 0 1.288000n 0 1.290000n 0 1.292000n 0 1.294000n 0 1.296000n 0 1.298000n 0 1.300000n 0 1.302000n 0 1.304000n 0 1.306000n 0 1.308000n 0 1.310000n 0 1.312000n 0 1.314000n 0 1.316000n 0 1.318000n 0 1.320000n 0 1.322000n 0 1.324000n 0 1.326000n 0 1.328000n 0 1.330000n 0 1.332000n 0 1.334000n 0 1.336000n 0 1.338000n 0 1.340000n 0 1.342000n 0 1.344000n 0 1.346000n 0 1.348000n 0 1.350000n 0 1.352000n 0 1.354000n 0 1.356000n 0 1.358000n 0 1.360000n 0 1.362000n 0 1.364000n 0 1.366000n 0 1.368000n 0 1.370000n 0 1.372000n 0 1.374000n 0 1.376000n 0 1.378000n 0 1.380000n 0 1.382000n 0 1.384000n 0 1.386000n 0 1.388000n 0 1.390000n 0 1.392000n 0 1.394000n 0 1.396000n 0 1.398000n 0 1.400000n 0 1.402000n 0 1.404000n 0 1.406000n 0 1.408000n 0 1.410000n 0 1.412000n 0 1.414000n 0 1.416000n 0 1.418000n 0 1.420000n 0 1.422000n 0 1.424000n 0 1.426000n 0 1.428000n 0 1.430000n 0 1.432000n 0 1.434000n 0 1.436000n 0 1.438000n 0 1.440000n 0 1.442000n 0 1.444000n 0 1.446000n 0 1.448000n 0 1.450000n 0 1.452000n 0 1.454000n 0 1.456000n 0 1.458000n 0 1.460000n 0 1.462000n 0 1.464000n 0 1.466000n 0 1.468000n 0 1.470000n 0 1.472000n 0 1.474000n 0 1.476000n 0 1.478000n 0 1.480000n 0 1.482000n 0 1.484000n 0 1.486000n 0 1.488000n 0 1.490000n 0 1.492000n 0 1.494000n 0 1.496000n 0 1.498000n 0 1.500000n 0 1.502000n 0 1.504000n 0 1.506000n 0 1.508000n 0 1.510000n 0 1.512000n 0 1.514000n 0 1.516000n 0 1.518000n 0 1.520000n 0 1.522000n 0 1.524000n 0 1.526000n 0 1.528000n 0 1.530000n 0 1.532000n 0 1.534000n 0 1.536000n 0 1.538000n 0 1.540000n 0 1.542000n 0 1.544000n 0 1.546000n 0 1.548000n 0 1.550000n 0 1.552000n 0 1.554000n 0 1.556000n 0 1.558000n 0 1.560000n 0 1.562000n 0 1.564000n 0 1.566000n 0 1.568000n 0 1.570000n 0 1.572000n 0 1.574000n 0 1.576000n 0 1.578000n 0 1.580000n 0 1.582000n 0 1.584000n 0 1.586000n 0 1.588000n 0 1.590000n 0 1.592000n 0 1.594000n 0 1.596000n 0 1.598000n 0 1.600000n 0 1.602000n 0 1.604000n 0 1.606000n 0 1.608000n 0 1.610000n 0 1.612000n 0 1.614000n 0 1.616000n 0 1.618000n 0 1.620000n 0 1.622000n 0 1.624000n 0 1.626000n 0 1.628000n 0 1.630000n 0 1.632000n 0 1.634000n 0 1.636000n 0 1.638000n 0 1.640000n 0 1.642000n 0 1.644000n 0 1.646000n 0 1.648000n 0 1.650000n 0 1.652000n 0 1.654000n 0 1.656000n 0 1.658000n 0 1.660000n 0 1.662000n 0 1.664000n 0 1.666000n 0 1.668000n 0 1.670000n 0 1.672000n 0 1.674000n 0 1.676000n 0 1.678000n 0 1.680000n 0 1.682000n 0 1.684000n 0 1.686000n 0 1.688000n 0 1.690000n 0 1.692000n 0 1.694000n 0 1.696000n 0 1.698000n 0 1.700000n 0 1.702000n 0 1.704000n 0 1.706000n 0 1.708000n 0 1.710000n 0 1.712000n 0 1.714000n 0 1.716000n 0 1.718000n 0 1.720000n 0 1.722000n 0 1.724000n 0 1.726000n 0 1.728000n 0 1.730000n 0 1.732000n 0 1.734000n 0 1.736000n 0 1.738000n 0 1.740000n 0 1.742000n 0 1.744000n 0 1.746000n 0 1.748000n 0 1.750000n 0 1.752000n 0 1.754000n 0 1.756000n 0 1.758000n 0 1.760000n 0 1.762000n 0 1.764000n 0 1.766000n 0 1.768000n 0 1.770000n 0 1.772000n 0 1.774000n 0 1.776000n 0 1.778000n 0 1.780000n 0 1.782000n 0 1.784000n 0 1.786000n 0 1.788000n 0 1.790000n 0 1.792000n 0 1.794000n 0 1.796000n 0 1.798000n 0 1.800000n 0 1.802000n 0 1.804000n 0 1.806000n 0 1.808000n 0 1.810000n 0 1.812000n 0 1.814000n 0 1.816000n 0 1.818000n 0 1.820000n 0 1.822000n 0 1.824000n 0 1.826000n 0 1.828000n 0 1.830000n 0 1.832000n 0 1.834000n 0 1.836000n 0 1.838000n 0 1.840000n 0 1.842000n 0 1.844000n 0 1.846000n 0 1.848000n 0 1.850000n 0 1.852000n 0 1.854000n 0 1.856000n 0 1.858000n 0 1.860000n 0 1.862000n 0 1.864000n 0 1.866000n 0 1.868000n 0 1.870000n 0 1.872000n 0 1.874000n 0 1.876000n 0 1.878000n 0 1.880000n 0 1.882000n 0 1.884000n 0 1.886000n 0 1.888000n 0 1.890000n 0 1.892000n 0 1.894000n 0 1.896000n 0 1.898000n 0 1.900000n 0 1.902000n 0 1.904000n 0 1.906000n 0 1.908000n 0 1.910000n 0 1.912000n 0 1.914000n 0 1.916000n 0 1.918000n 0 1.920000n 0 1.922000n 0 1.924000n 0 1.926000n 0 1.928000n 0 1.930000n 0 1.932000n 0 1.934000n 0 1.936000n 0 1.938000n 0 1.940000n 0 1.942000n 0 1.944000n 0 1.946000n 0 1.948000n 0 1.950000n 0 1.952000n 0 1.954000n 0 1.956000n 0 1.958000n 0 1.960000n 0 1.962000n 0 1.964000n 0 1.966000n 0 1.968000n 0 1.970000n 0 1.972000n 0 1.974000n 0 1.976000n 0 1.978000n 0 1.980000n 0 1.982000n 0 1.984000n 0 1.986000n 0 1.988000n 0 1.990000n 0 1.992000n 0 1.994000n 0 1.996000n 0 1.998000n 0 2.000000n 0 2.002000n 0 2.004000n 0 2.006000n 0 2.008000n 0 2.010000n 0 2.012000n 0 2.014000n 0 2.016000n 0 2.018000n 0 2.020000n 0 2.022000n 0 2.024000n 0 2.026000n 0 2.028000n 0 2.030000n 0 2.032000n 0 2.034000n 0 2.036000n 0 2.038000n 0 2.040000n 0 2.042000n 0 2.044000n 0 2.046000n 0 2.048000n 0 2.050000n 0 2.052000n 0 2.054000n 0 2.056000n 0 2.058000n 0 2.060000n 0 2.062000n 0 2.064000n 0 2.066000n 0 2.068000n 0 2.070000n 0 2.072000n 0 2.074000n 0 2.076000n 0 2.078000n 0 2.080000n 0 2.082000n 0 2.084000n 0 2.086000n 0 2.088000n 0 2.090000n 0 2.092000n 0 2.094000n 0 2.096000n 0 2.098000n 0 2.100000n 0 2.102000n 0 2.104000n 0 2.106000n 0 2.108000n 0 2.110000n 0 2.112000n 0 2.114000n 0 2.116000n 0 2.118000n 0 2.120000n 0 2.122000n 0 2.124000n 0 2.126000n 0 2.128000n 0 2.130000n 0 2.132000n 0 2.134000n 0 2.136000n 0 2.138000n 0 2.140000n 0 2.142000n 0 2.144000n 0 2.146000n 0 2.148000n 0 2.150000n 0 2.152000n 0 2.154000n 0 2.156000n 0 2.158000n 0 2.160000n 0 2.162000n 0 2.164000n 0 2.166000n 0 2.168000n 0 2.170000n 0 2.172000n 0 2.174000n 0 2.176000n 0 2.178000n 0 2.180000n 0 2.182000n 0 2.184000n 0 2.186000n 0 2.188000n 0 2.190000n 0 2.192000n 0 2.194000n 0 2.196000n 0 2.198000n 0 2.200000n 0 2.202000n 0 2.204000n 0 2.206000n 0 2.208000n 0 2.210000n 0 2.212000n 0 2.214000n 0 2.216000n 0 2.218000n 0 2.220000n 0 2.222000n 0 2.224000n 0 2.226000n 0 2.228000n 0 2.230000n 0 2.232000n 0 2.234000n 0 2.236000n 0 2.238000n 0 2.240000n 0 2.242000n 0 2.244000n 0 2.246000n 0 2.248000n 0 2.250000n 0 2.252000n 0 2.254000n 0 2.256000n 0 2.258000n 0 2.260000n 0 2.262000n 0 2.264000n 0 2.266000n 0 2.268000n 0 2.270000n 0 2.272000n 0 2.274000n 0 2.276000n 0 2.278000n 0 2.280000n 0 2.282000n 0 2.284000n 0 2.286000n 0 2.288000n 0 2.290000n 0 2.292000n 0 2.294000n 0 2.296000n 0 2.298000n 0 2.300000n 0 2.302000n 0 2.304000n 0 2.306000n 0 2.308000n 0 2.310000n 0 2.312000n 0 2.314000n 0 2.316000n 0 2.318000n 0 2.320000n 0 2.322000n 0 2.324000n 0 2.326000n 0 2.328000n 0 2.330000n 0 2.332000n 0 2.334000n 0 2.336000n 0 2.338000n 0 2.340000n 0 2.342000n 0 2.344000n 0 2.346000n 0 2.348000n 0 2.350000n 0 2.352000n 0 2.354000n 0 2.356000n 0 2.358000n 0 2.360000n 0 2.362000n 0 2.364000n 0 2.366000n 0 2.368000n 0 2.370000n 0 2.372000n 0 2.374000n 0 2.376000n 0 2.378000n 0 2.380000n 0 2.382000n 0 2.384000n 0 2.386000n 0 2.388000n 0 2.390000n 0 2.392000n 0 2.394000n 0 2.396000n 0 2.398000n 0 2.400000n 0 2.402000n 0 2.404000n 0 2.406000n 0 2.408000n 0 2.410000n 0 2.412000n 0 2.414000n 0 2.416000n 0 2.418000n 0 2.420000n 0 2.422000n 0 2.424000n 0 2.426000n 0 2.428000n 0 2.430000n 0 2.432000n 0 2.434000n 0 2.436000n 0 2.438000n 0 2.440000n 0 2.442000n 0 2.444000n 0 2.446000n 0 2.448000n 0 2.450000n 0 2.452000n 0 2.454000n 0 2.456000n 0 2.458000n 0 2.460000n 0 2.462000n 0 2.464000n 0 2.466000n 0 2.468000n 0 2.470000n 0 2.472000n 0 2.474000n 0 2.476000n 0 2.478000n 0 2.480000n 0 2.482000n 0 2.484000n 0 2.486000n 0 2.488000n 0 2.490000n 0 2.492000n 0 2.494000n 0 2.496000n 0 2.498000n 0 2.500000n 0 2.502000n 0 2.504000n 0 2.506000n 0 2.508000n 0 2.510000n 0 2.512000n 0 2.514000n 0 2.516000n 0 2.518000n 0 2.520000n 0 2.522000n 0 2.524000n 0 2.526000n 0 2.528000n 0 2.530000n 0 2.532000n 0 2.534000n 0 2.536000n 0 2.538000n 0 2.540000n 0 2.542000n 0 2.544000n 0 2.546000n 0 2.548000n 0 2.550000n 0 2.552000n 0 2.554000n 0 2.556000n 0 2.558000n 0 2.560000n 0 2.562000n 0 2.564000n 0 2.566000n 0 2.568000n 0 2.570000n 0 2.572000n 0 2.574000n 0 2.576000n 0 2.578000n 0 2.580000n 0 2.582000n 0 2.584000n 0 2.586000n 0 2.588000n 0 2.590000n 0 2.592000n 0 2.594000n 0 2.596000n 0 2.598000n 0 2.600000n 0 2.602000n 0 2.604000n 0 2.606000n 0 2.608000n 0 2.610000n 0 2.612000n 0 2.614000n 0 2.616000n 0 2.618000n 0 2.620000n 0 2.622000n 0 2.624000n 0 2.626000n 0 2.628000n 0 2.630000n 0 2.632000n 0 2.634000n 0 2.636000n 0 2.638000n 0 2.640000n 0 2.642000n 0 2.644000n 0 2.646000n 0 2.648000n 0 2.650000n 0 2.652000n 0 2.654000n 0 2.656000n 0 2.658000n 0 2.660000n 0 2.662000n 0 2.664000n 0 2.666000n 0 2.668000n 0 2.670000n 0 2.672000n 0 2.674000n 0 2.676000n 0 2.678000n 0 2.680000n 0 2.682000n 0 2.684000n 0 2.686000n 0 2.688000n 0 2.690000n 0 2.692000n 0 2.694000n 0 2.696000n 0 2.698000n 0 2.700000n 0 2.702000n 0 2.704000n 0 2.706000n 0 2.708000n 0 2.710000n 0 2.712000n 0 2.714000n 0 2.716000n 0 2.718000n 0 2.720000n 0 2.722000n 0 2.724000n 0 2.726000n 0 2.728000n 0 2.730000n 0 2.732000n 0 2.734000n 0 2.736000n 0 2.738000n 0 2.740000n 0 2.742000n 0 2.744000n 0 2.746000n 0 2.748000n 0 2.750000n 0 2.752000n 0 2.754000n 0 2.756000n 0 2.758000n 0 2.760000n 0 2.762000n 0 2.764000n 0 2.766000n 0 2.768000n 0 2.770000n 0 2.772000n 0 2.774000n 0 2.776000n 0 2.778000n 0 2.780000n 0 2.782000n 0 2.784000n 0 2.786000n 0 2.788000n 0 2.790000n 0 2.792000n 0 2.794000n 0 2.796000n 0 2.798000n 0 2.800000n 0 2.802000n 0 2.804000n 0 2.806000n 0 2.808000n 0 2.810000n 0 2.812000n 0 2.814000n 0 2.816000n 0 2.818000n 0 2.820000n 0 2.822000n 0 2.824000n 0 2.826000n 0 2.828000n 0 2.830000n 0 2.832000n 0 2.834000n 0 2.836000n 0 2.838000n 0 2.840000n 0 2.842000n 0 2.844000n 0 2.846000n 0 2.848000n 0 2.850000n 0 2.852000n 0 2.854000n 0 2.856000n 0 2.858000n 0 2.860000n 0 2.862000n 0 2.864000n 0 2.866000n 0 2.868000n 0 2.870000n 0 2.872000n 0 2.874000n 0 2.876000n 0 2.878000n 0 2.880000n 0 2.882000n 0 2.884000n 0 2.886000n 0 2.888000n 0 2.890000n 0 2.892000n 0 2.894000n 0 2.896000n 0 2.898000n 0 2.900000n 0 2.902000n 0 2.904000n 0 2.906000n 0 2.908000n 0 2.910000n 0 2.912000n 0 2.914000n 0 2.916000n 0 2.918000n 0 2.920000n 0 2.922000n 0 2.924000n 0 2.926000n 0 2.928000n 0 2.930000n 0 2.932000n 0 2.934000n 0 2.936000n 0 2.938000n 0 2.940000n 0 2.942000n 0 2.944000n 0 2.946000n 0 2.948000n 0 2.950000n 0 2.952000n 0 2.954000n 0 2.956000n 0 2.958000n 0 2.960000n 0 2.962000n 0 2.964000n 0 2.966000n 0 2.968000n 0 2.970000n 0 2.972000n 0 2.974000n 0 2.976000n 0 2.978000n 0 2.980000n 0 2.982000n 0 2.984000n 0 2.986000n 0 2.988000n 0 2.990000n 0 2.992000n 0 2.994000n 0 2.996000n 0 2.998000n 0 3.000000n 0 3.002000n 0 3.004000n 0 3.006000n 0 3.008000n 0 3.010000n 0 3.012000n 0 3.014000n 0 3.016000n 0 3.018000n 0 3.020000n 0 3.022000n 0 3.024000n 0 3.026000n 0 3.028000n 0 3.030000n 0 3.032000n 0 3.034000n 0 3.036000n 0 3.038000n 0 3.040000n 0 3.042000n 0 3.044000n 0 3.046000n 0 3.048000n 0 3.050000n 0 3.052000n 0 3.054000n 0 3.056000n 0 3.058000n 0 3.060000n 0 3.062000n 0 3.064000n 0 3.066000n 0 3.068000n 0 3.070000n 0 3.072000n 0 3.074000n 0 3.076000n 0 3.078000n 0 3.080000n 0 3.082000n 0 3.084000n 0 3.086000n 0 3.088000n 0 3.090000n 0 3.092000n 0 3.094000n 0 3.096000n 0 3.098000n 0 3.100000n 0 3.102000n 0 3.104000n 0 3.106000n 0 3.108000n 0 3.110000n 0 3.112000n 0 3.114000n 0 3.116000n 0 3.118000n 0 3.120000n 0 3.122000n 0 3.124000n 0 3.126000n 0 3.128000n 0 3.130000n 0 3.132000n 0 3.134000n 0 3.136000n 0 3.138000n 0 3.140000n 0 3.142000n 0 3.144000n 0 3.146000n 0 3.148000n 0 3.150000n 0 3.152000n 0 3.154000n 0 3.156000n 0 3.158000n 0 3.160000n 0 3.162000n 0 3.164000n 0 3.166000n 0 3.168000n 0 3.170000n 0 3.172000n 0 3.174000n 0 3.176000n 0 3.178000n 0 3.180000n 0 3.182000n 0 3.184000n 0 3.186000n 0 3.188000n 0 3.190000n 0 3.192000n 0 3.194000n 0 3.196000n 0 3.198000n 0 3.200000n 0 3.202000n 0 3.204000n 0 3.206000n 0 3.208000n 0 3.210000n 0 3.212000n 0 3.214000n 0 3.216000n 0 3.218000n 0 3.220000n 0 3.222000n 0 3.224000n 0 3.226000n 0 3.228000n 0 3.230000n 0 3.232000n 0 3.234000n 0 3.236000n 0 3.238000n 0 3.240000n 0 3.242000n 0 3.244000n 0 3.246000n 0 3.248000n 0 3.250000n 0 3.252000n 0 3.254000n 0 3.256000n 0 3.258000n 0 3.260000n 0 3.262000n 0 3.264000n 0 3.266000n 0 3.268000n 0 3.270000n 0 3.272000n 0 3.274000n 0 3.276000n 0 3.278000n 0 3.280000n 0 3.282000n 0 3.284000n 0 3.286000n 0 3.288000n 0 3.290000n 0 3.292000n 0 3.294000n 0 3.296000n 0 3.298000n 0 3.300000n 0 3.302000n 0 3.304000n 0 3.306000n 0 3.308000n 0 3.310000n 0 3.312000n 0 3.314000n 0 3.316000n 0 3.318000n 0 3.320000n 0 3.322000n 0 3.324000n 0 3.326000n 0 3.328000n 0 3.330000n 0 3.332000n 0 3.334000n 0 3.336000n 0 3.338000n 0 3.340000n 0 3.342000n 0 3.344000n 0 3.346000n 0 3.348000n 0 3.350000n 0 3.352000n 0 3.354000n 0 3.356000n 0 3.358000n 0 3.360000n 0 3.362000n 0 3.364000n 0 3.366000n 0 3.368000n 0 3.370000n 0 3.372000n 0 3.374000n 0 3.376000n 0 3.378000n 0 3.380000n 0 3.382000n 0 3.384000n 0 3.386000n 0 3.388000n 0 3.390000n 0 3.392000n 0 3.394000n 0 3.396000n 0 3.398000n 0 3.400000n 0 3.402000n 0 3.404000n 0 3.406000n 0 3.408000n 0 3.410000n 0 3.412000n 0 3.414000n 0 3.416000n 0 3.418000n 0 3.420000n 0 3.422000n 0 3.424000n 0 3.426000n 0 3.428000n 0 3.430000n 0 3.432000n 0 3.434000n 0 3.436000n 0 3.438000n 0 3.440000n 0 3.442000n 0 3.444000n 0 3.446000n 0 3.448000n 0 3.450000n 0 3.452000n 0 3.454000n 0 3.456000n 0 3.458000n 0 3.460000n 0 3.462000n 0 3.464000n 0 3.466000n 0 3.468000n 0 3.470000n 0 3.472000n 0 3.474000n 0 3.476000n 0 3.478000n 0 3.480000n 0 3.482000n 0 3.484000n 0 3.486000n 0 3.488000n 0 3.490000n 0 3.492000n 0 3.494000n 0 3.496000n 0 3.498000n 0 3.500000n 0 3.502000n 0 3.504000n 0 3.506000n 0 3.508000n 0 3.510000n 0 3.512000n 0 3.514000n 0 3.516000n 0 3.518000n 0 3.520000n 0 3.522000n 0 3.524000n 0 3.526000n 0 3.528000n 0 3.530000n 0 3.532000n 0 3.534000n 0 3.536000n 0 3.538000n 0 3.540000n 0 3.542000n 0 3.544000n 0 3.546000n 0 3.548000n 0 3.550000n 0 3.552000n 0 3.554000n 0 3.556000n 0 3.558000n 0 3.560000n 0 3.562000n 0 3.564000n 0 3.566000n 0 3.568000n 0 3.570000n 0 3.572000n 0 3.574000n 0 3.576000n 0 3.578000n 0 3.580000n 0 3.582000n 0 3.584000n 0 3.586000n 0 3.588000n 0 3.590000n 0 3.592000n 0 3.594000n 0 3.596000n 0 3.598000n 0 3.600000n 0 3.602000n 0 3.604000n 0 3.606000n 0 3.608000n 0 3.610000n 0 3.612000n 0 3.614000n 0 3.616000n 0 3.618000n 0 3.620000n 0 3.622000n 0 3.624000n 0 3.626000n 0 3.628000n 0 3.630000n 0 3.632000n 0 3.634000n 0 3.636000n 0 3.638000n 0 3.640000n 0 3.642000n 0 3.644000n 0 3.646000n 0 3.648000n 0 3.650000n 0 3.652000n 0 3.654000n 0 3.656000n 0 3.658000n 0 3.660000n 0 3.662000n 0 3.664000n 0 3.666000n 0 3.668000n 0 3.670000n 0 3.672000n 0 3.674000n 0 3.676000n 0 3.678000n 0 3.680000n 0 3.682000n 0 3.684000n 0 3.686000n 0 3.688000n 0 3.690000n 0 3.692000n 0 3.694000n 0 3.696000n 0 3.698000n 0 3.700000n 0 3.702000n 0 3.704000n 0 3.706000n 0 3.708000n 0 3.710000n 0 3.712000n 0 3.714000n 0 3.716000n 0 3.718000n 0 3.720000n 0 3.722000n 0 3.724000n 0 3.726000n 0 3.728000n 0 3.730000n 0 3.732000n 0 3.734000n 0 3.736000n 0 3.738000n 0 3.740000n 0 3.742000n 0 3.744000n 0 3.746000n 0 3.748000n 0 3.750000n 0 3.752000n 0 3.754000n 0 3.756000n 0 3.758000n 0 3.760000n 0 3.762000n 0 3.764000n 0 3.766000n 0 3.768000n 0 3.770000n 0 3.772000n 0 3.774000n 0 3.776000n 0 3.778000n 0 3.780000n 0 3.782000n 0 3.784000n 0 3.786000n 0 3.788000n 0 3.790000n 0 3.792000n 0 3.794000n 0 3.796000n 0 3.798000n 0 3.800000n 0 3.802000n 0 3.804000n 0 3.806000n 0 3.808000n 0 3.810000n 0 3.812000n 0 3.814000n 0 3.816000n 0 3.818000n 0 3.820000n 0 3.822000n 0 3.824000n 0 3.826000n 0 3.828000n 0 3.830000n 0 3.832000n 0 3.834000n 0 3.836000n 0 3.838000n 0 3.840000n 0 3.842000n 0 3.844000n 0 3.846000n 0 3.848000n 0 3.850000n 0 3.852000n 0 3.854000n 0 3.856000n 0 3.858000n 0 3.860000n 0 3.862000n 0 3.864000n 0 3.866000n 0 3.868000n 0 3.870000n 0 3.872000n 0 3.874000n 0 3.876000n 0 3.878000n 0 3.880000n 0 3.882000n 0 3.884000n 0 3.886000n 0 3.888000n 0 3.890000n 0 3.892000n 0 3.894000n 0 3.896000n 0 3.898000n 0 3.900000n 0 3.902000n 0 3.904000n 0 3.906000n 0 3.908000n 0 3.910000n 0 3.912000n 0 3.914000n 0 3.916000n 0 3.918000n 0 3.920000n 0 3.922000n 0 3.924000n 0 3.926000n 0 3.928000n 0 3.930000n 0 3.932000n 0 3.934000n 0 3.936000n 0 3.938000n 0 3.940000n 0 3.942000n 0 3.944000n 0 3.946000n 0 3.948000n 0 3.950000n 0 3.952000n 0 3.954000n 0 3.956000n 0 3.958000n 0 3.960000n 0 3.962000n 0 3.964000n 0 3.966000n 0 3.968000n 0 3.970000n 0 3.972000n 0 3.974000n 0 3.976000n 0 3.978000n 0 3.980000n 0 3.982000n 0 3.984000n 0 3.986000n 0 3.988000n 0 3.990000n 0 3.992000n 0 3.994000n 0 3.996000n 0 3.998000n 0 4.000000n 0 4.002000n 0 4.004000n 0 4.006000n 0 4.008000n 0 4.010000n 0 4.012000n 0 4.014000n 0 4.016000n 0 4.018000n 0 4.020000n 0 4.022000n 0 4.024000n 0 4.026000n 0 4.028000n 0 4.030000n 0 4.032000n 0 4.034000n 0 4.036000n 0 4.038000n 0 4.040000n 0 4.042000n 0 4.044000n 0 4.046000n 0 4.048000n 0 4.050000n 0 4.052000n 0 4.054000n 0 4.056000n 0 4.058000n 0 4.060000n 0 4.062000n 0 4.064000n 0 4.066000n 0 4.068000n 0 4.070000n 0 4.072000n 0 4.074000n 0 4.076000n 0 4.078000n 0 4.080000n 0 4.082000n 0 4.084000n 0 4.086000n 0 4.088000n 0 4.090000n 0 4.092000n 0 4.094000n 0 4.096000n 0 4.098000n 0 4.100000n 0 4.102000n 0 4.104000n 0 4.106000n 0 4.108000n 0 4.110000n 0 4.112000n 0 4.114000n 0 4.116000n 0 4.118000n 0 4.120000n 0 4.122000n 0 4.124000n 0 4.126000n 0 4.128000n 0 4.130000n 0 4.132000n 0 4.134000n 0 4.136000n 0 4.138000n 0 4.140000n 0 4.142000n 0 4.144000n 0 4.146000n 0 4.148000n 0 4.150000n 0 4.152000n 0 4.154000n 0 4.156000n 0 4.158000n 0 4.160000n 0 4.162000n 0 4.164000n 0 4.166000n 0 4.168000n 0 4.170000n 0 4.172000n 0 4.174000n 0 4.176000n 0 4.178000n 0 4.180000n 0 4.182000n 0 4.184000n 0 4.186000n 0 4.188000n 0 4.190000n 0 4.192000n 0 4.194000n 0 4.196000n 0 4.198000n 0 4.200000n 0 4.202000n 0 4.204000n 0 4.206000n 0 4.208000n 0 4.210000n 0 4.212000n 0 4.214000n 0 4.216000n 0 4.218000n 0 4.220000n 0 4.222000n 0 4.224000n 0 4.226000n 0 4.228000n 0 4.230000n 0 4.232000n 0 4.234000n 0 4.236000n 0 4.238000n 0 4.240000n 0 4.242000n 0 4.244000n 0 4.246000n 0 4.248000n 0 4.250000n 0 4.252000n 0 4.254000n 0 4.256000n 0 4.258000n 0 4.260000n 0 4.262000n 0 4.264000n 0 4.266000n 0 4.268000n 0 4.270000n 0 4.272000n 0 4.274000n 0 4.276000n 0 4.278000n 0 4.280000n 0 4.282000n 0 4.284000n 0 4.286000n 0 4.288000n 0 4.290000n 0 4.292000n 0 4.294000n 0 4.296000n 0 4.298000n 0 4.300000n 0 4.302000n 0 4.304000n 0 4.306000n 0 4.308000n 0 4.310000n 0 4.312000n 0 4.314000n 0 4.316000n 0 4.318000n 0 4.320000n 0 4.322000n 0 4.324000n 0 4.326000n 0 4.328000n 0 4.330000n 0 4.332000n 0 4.334000n 0 4.336000n 0 4.338000n 0 4.340000n 0 4.342000n 0 4.344000n 0 4.346000n 0 4.348000n 0 4.350000n 0 4.352000n 0 4.354000n 0 4.356000n 0 4.358000n 0 4.360000n 0 4.362000n 0 4.364000n 0 4.366000n 0 4.368000n 0 4.370000n 0 4.372000n 0 4.374000n 0 4.376000n 0 4.378000n 0 4.380000n 0 4.382000n 0 4.384000n 0 4.386000n 0 4.388000n 0 4.390000n 0 4.392000n 0 4.394000n 0 4.396000n 0 4.398000n 0 4.400000n 0 4.402000n 0 4.404000n 0 4.406000n 0 4.408000n 0 4.410000n 0 4.412000n 0 4.414000n 0 4.416000n 0 4.418000n 0 4.420000n 0 4.422000n 0 4.424000n 0 4.426000n 0 4.428000n 0 4.430000n 0 4.432000n 0 4.434000n 0 4.436000n 0 4.438000n 0 4.440000n 0 4.442000n 0 4.444000n 0 4.446000n 0 4.448000n 0 4.450000n 0 4.452000n 0 4.454000n 0 4.456000n 0 4.458000n 0 4.460000n 0 4.462000n 0 4.464000n 0 4.466000n 0 4.468000n 0 4.470000n 0 4.472000n 0 4.474000n 0 4.476000n 0 4.478000n 0 4.480000n 0 4.482000n 0 4.484000n 0 4.486000n 0 4.488000n 0 4.490000n 0 4.492000n 0 4.494000n 0 4.496000n 0 4.498000n 0 4.500000n 0 4.502000n 0 4.504000n 0 4.506000n 0 4.508000n 0 4.510000n 0 4.512000n 0 4.514000n 0 4.516000n 0 4.518000n 0 4.520000n 0 4.522000n 0 4.524000n 0 4.526000n 0 4.528000n 0 4.530000n 0 4.532000n 0 4.534000n 0 4.536000n 0 4.538000n 0 4.540000n 0 4.542000n 0 4.544000n 0 4.546000n 0 4.548000n 0 4.550000n 0 4.552000n 0 4.554000n 0 4.556000n 0 4.558000n 0 4.560000n 0 4.562000n 0 4.564000n 0 4.566000n 0 4.568000n 0 4.570000n 0 4.572000n 0 4.574000n 0 4.576000n 0 4.578000n 0 4.580000n 0 4.582000n 0 4.584000n 0 4.586000n 0 4.588000n 0 4.590000n 0 4.592000n 0 4.594000n 0 4.596000n 0 4.598000n 0 4.600000n 0 4.602000n 0 4.604000n 0 4.606000n 0 4.608000n 0 4.610000n 0 4.612000n 0 4.614000n 0 4.616000n 0 4.618000n 0 4.620000n 0 4.622000n 0 4.624000n 0 4.626000n 0 4.628000n 0 4.630000n 0 4.632000n 0 4.634000n 0 4.636000n 0 4.638000n 0 4.640000n 0 4.642000n 0 4.644000n 0 4.646000n 0 4.648000n 0 4.650000n 0 4.652000n 0 4.654000n 0 4.656000n 0 4.658000n 0 4.660000n 0 4.662000n 0 4.664000n 0 4.666000n 0 4.668000n 0 4.670000n 0 4.672000n 0 4.674000n 0 4.676000n 0 4.678000n 0 4.680000n 0 4.682000n 0 4.684000n 0 4.686000n 0 4.688000n 0 4.690000n 0 4.692000n 0 4.694000n 0 4.696000n 0 4.698000n 0 4.700000n 0 4.702000n 0 4.704000n 0 4.706000n 0 4.708000n 0 4.710000n 0 4.712000n 0 4.714000n 0 4.716000n 0 4.718000n 0 4.720000n 0 4.722000n 0 4.724000n 0 4.726000n 0 4.728000n 0 4.730000n 0 4.732000n 0 4.734000n 0 4.736000n 0 4.738000n 0 4.740000n 0 4.742000n 0 4.744000n 0 4.746000n 0 4.748000n 0 4.750000n 0 4.752000n 0 4.754000n 0 4.756000n 0 4.758000n 0 4.760000n 0 4.762000n 0 4.764000n 0 4.766000n 0 4.768000n 0 4.770000n 0 4.772000n 0 4.774000n 0 4.776000n 0 4.778000n 0 4.780000n 0 4.782000n 0 4.784000n 0 4.786000n 0 4.788000n 0 4.790000n 0 4.792000n 0 4.794000n 0 4.796000n 0 4.798000n 0 4.800000n 0 4.802000n 0 4.804000n 0 4.806000n 0 4.808000n 0 4.810000n 0 4.812000n 0 4.814000n 0 4.816000n 0 4.818000n 0 4.820000n 0 4.822000n 0 4.824000n 0 4.826000n 0 4.828000n 0 4.830000n 0 4.832000n 0 4.834000n 0 4.836000n 0 4.838000n 0 4.840000n 0 4.842000n 0 4.844000n 0 4.846000n 0 4.848000n 0 4.850000n 0 4.852000n 0 4.854000n 0 4.856000n 0 4.858000n 0 4.860000n 0 4.862000n 0 4.864000n 0 4.866000n 0 4.868000n 0 4.870000n 0 4.872000n 0 4.874000n 0 4.876000n 0 4.878000n 0 4.880000n 0 4.882000n 0 4.884000n 0 4.886000n 0 4.888000n 0 4.890000n 0 4.892000n 0 4.894000n 0 4.896000n 0 4.898000n 0 4.900000n 0 4.902000n 0 4.904000n 0 4.906000n 0 4.908000n 0 4.910000n 0 4.912000n 0 4.914000n 0 4.916000n 0 4.918000n 0 4.920000n 0 4.922000n 0 4.924000n 0 4.926000n 0 4.928000n 0 4.930000n 0 4.932000n 0 4.934000n 0 4.936000n 0 4.938000n 0 4.940000n 0 4.942000n 0 4.944000n 0 4.946000n 0 4.948000n 0 4.950000n 0 4.952000n 0 4.954000n 0 4.956000n 0 4.958000n 0 4.960000n 0 4.962000n 0 4.964000n 0 4.966000n 0 4.968000n 0 4.970000n 0 4.972000n 0 4.974000n 0 4.976000n 0 4.978000n 0 4.980000n 0 4.982000n 0 4.984000n 0 4.986000n 0 4.988000n 0 4.990000n 0 4.992000n 0 4.994000n 0 4.996000n 0 4.998000n 0 5.000000n 0 5.002000n 0 5.004000n 0 5.006000n 0 5.008000n 0 5.010000n 0 5.012000n 0 5.014000n 0 5.016000n 0 5.018000n 0 5.020000n 0 5.022000n 0 5.024000n 0 5.026000n 0 5.028000n 0 5.030000n 0 5.032000n 0 5.034000n 0 5.036000n 0 5.038000n 0 5.040000n 0 5.042000n 0 5.044000n 0 5.046000n 0 5.048000n 0 5.050000n 0 5.052000n 0 5.054000n 0 5.056000n 0 5.058000n 0 5.060000n 0 5.062000n 0 5.064000n 0 5.066000n 0 5.068000n 0 5.070000n 0 5.072000n 0 5.074000n 0 5.076000n 0 5.078000n 0 5.080000n 0 5.082000n 0 5.084000n 0 5.086000n 0 5.088000n 0 5.090000n 0 5.092000n 0 5.094000n 0 5.096000n 0 5.098000n 0 5.100000n 0 5.102000n 0 5.104000n 0 5.106000n 0 5.108000n 0 5.110000n 0 5.112000n 0 5.114000n 0 5.116000n 0 5.118000n 0 5.120000n 0 5.122000n 0 5.124000n 0 5.126000n 0 5.128000n 0 5.130000n 0 5.132000n 0 5.134000n 0 5.136000n 0 5.138000n 0 5.140000n 0 5.142000n 0 5.144000n 0 5.146000n 0 5.148000n 0 5.150000n 0 5.152000n 0 5.154000n 0 5.156000n 0 5.158000n 0 5.160000n 0 5.162000n 0 5.164000n 0 5.166000n 0 5.168000n 0 5.170000n 0 5.172000n 0 5.174000n 0 5.176000n 0 5.178000n 0 5.180000n 0 5.182000n 0 5.184000n 0 5.186000n 0 5.188000n 0 5.190000n 0 5.192000n 0 5.194000n 0 5.196000n 0 5.198000n 0 5.200000n 0 5.202000n 0 5.204000n 0 5.206000n 0 5.208000n 0 5.210000n 0 5.212000n 0 5.214000n 0 5.216000n 0 5.218000n 0 5.220000n 0 5.222000n 0 5.224000n 0 5.226000n 0 5.228000n 0 5.230000n 0 5.232000n 0 5.234000n 0 5.236000n 0 5.238000n 0 5.240000n 0 5.242000n 0 5.244000n 0 5.246000n 0 5.248000n 0 5.250000n 0 5.252000n 0 5.254000n 0 5.256000n 0 5.258000n 0 5.260000n 0 5.262000n 0 5.264000n 0 5.266000n 0 5.268000n 0 5.270000n 0 5.272000n 0 5.274000n 0 5.276000n 0 5.278000n 0 5.280000n 0 5.282000n 0 5.284000n 0 5.286000n 0 5.288000n 0 5.290000n 0 5.292000n 0 5.294000n 0 5.296000n 0 5.298000n 0 5.300000n 0 5.302000n 0 5.304000n 0 5.306000n 0 5.308000n 0 5.310000n 0 5.312000n 0 5.314000n 0 5.316000n 0 5.318000n 0 5.320000n 0 5.322000n 0 5.324000n 0 5.326000n 0 5.328000n 0 5.330000n 0 5.332000n 0 5.334000n 0 5.336000n 0 5.338000n 0 5.340000n 0 5.342000n 0 5.344000n 0 5.346000n 0 5.348000n 0 5.350000n 0 5.352000n 0 5.354000n 0 5.356000n 0 5.358000n 0 5.360000n 0 5.362000n 0 5.364000n 0 5.366000n 0 5.368000n 0 5.370000n 0 5.372000n 0 5.374000n 0 5.376000n 0 5.378000n 0 5.380000n 0 5.382000n 0 5.384000n 0 5.386000n 0 5.388000n 0 5.390000n 0 5.392000n 0 5.394000n 0 5.396000n 0 5.398000n 0 5.400000n 0 5.402000n 0 5.404000n 0 5.406000n 0 5.408000n 0 5.410000n 0 5.412000n 0 5.414000n 0 5.416000n 0 5.418000n 0 5.420000n 0 5.422000n 0 5.424000n 0 5.426000n 0 5.428000n 0 5.430000n 0 5.432000n 0 5.434000n 0 5.436000n 0 5.438000n 0 5.440000n 0 5.442000n 0 5.444000n 0 5.446000n 0 5.448000n 0 5.450000n 0 5.452000n 0 5.454000n 0 5.456000n 0 5.458000n 0 5.460000n 0 5.462000n 0 5.464000n 0 5.466000n 0 5.468000n 0 5.470000n 0 5.472000n 0 5.474000n 0 5.476000n 0 5.478000n 0 5.480000n 0 5.482000n 0 5.484000n 0 5.486000n 0 5.488000n 0 5.490000n 0 5.492000n 0 5.494000n 0 5.496000n 0 5.498000n 0 5.500000n 0 5.502000n 0 5.504000n 0 5.506000n 0 5.508000n 0 5.510000n 0 5.512000n 0 5.514000n 0 5.516000n 0 5.518000n 0 5.520000n 0 5.522000n 0 5.524000n 0 5.526000n 0 5.528000n 0 5.530000n 0 5.532000n 0 5.534000n 0 5.536000n 0 5.538000n 0 5.540000n 0 5.542000n 0 5.544000n 0 5.546000n 0 5.548000n 0 5.550000n 0 5.552000n 0 5.554000n 0 5.556000n 0 5.558000n 0 5.560000n 0 5.562000n 0 5.564000n 0 5.566000n 0 5.568000n 0 5.570000n 0 5.572000n 0 5.574000n 0 5.576000n 0 5.578000n 0 5.580000n 0 5.582000n 0 5.584000n 0 5.586000n 0 5.588000n 0 5.590000n 0 5.592000n 0 5.594000n 0 5.596000n 0 5.598000n 0 5.600000n 0 5.602000n 0 5.604000n 0 5.606000n 0 5.608000n 0 5.610000n 0 5.612000n 0 5.614000n 0 5.616000n 0 5.618000n 0 5.620000n 0 5.622000n 0 5.624000n 0 5.626000n 0 5.628000n 0 5.630000n 0 5.632000n 0 5.634000n 0 5.636000n 0 5.638000n 0 5.640000n 0 5.642000n 0 5.644000n 0 5.646000n 0 5.648000n 0 5.650000n 0 5.652000n 0 5.654000n 0 5.656000n 0 5.658000n 0 5.660000n 0 5.662000n 0 5.664000n 0 5.666000n 0 5.668000n 0 5.670000n 0 5.672000n 0 5.674000n 0 5.676000n 0 5.678000n 0 5.680000n 0 5.682000n 0 5.684000n 0 5.686000n 0 5.688000n 0 5.690000n 0 5.692000n 0 5.694000n 0 5.696000n 0 5.698000n 0 5.700000n 0 5.702000n 0 5.704000n 0 5.706000n 0 5.708000n 0 5.710000n 0 5.712000n 0 5.714000n 0 5.716000n 0 5.718000n 0 5.720000n 0 5.722000n 0 5.724000n 0 5.726000n 0 5.728000n 0 5.730000n 0 5.732000n 0 5.734000n 0 5.736000n 0 5.738000n 0 5.740000n 0 5.742000n 0 5.744000n 0 5.746000n 0 5.748000n 0 5.750000n 0 5.752000n 0 5.754000n 0 5.756000n 0 5.758000n 0 5.760000n 0 5.762000n 0 5.764000n 0 5.766000n 0 5.768000n 0 5.770000n 0 5.772000n 0 5.774000n 0 5.776000n 0 5.778000n 0 5.780000n 0 5.782000n 0 5.784000n 0 5.786000n 0 5.788000n 0 5.790000n 0 5.792000n 0 5.794000n 0 5.796000n 0 5.798000n 0 5.800000n 0 5.802000n 0 5.804000n 0 5.806000n 0 5.808000n 0 5.810000n 0 5.812000n 0 5.814000n 0 5.816000n 0 5.818000n 0 5.820000n 0 5.822000n 0 5.824000n 0 5.826000n 0 5.828000n 0 5.830000n 0 5.832000n 0 5.834000n 0 5.836000n 0 5.838000n 0 5.840000n 0 5.842000n 0 5.844000n 0 5.846000n 0 5.848000n 0 5.850000n 0 5.852000n 0 5.854000n 0 5.856000n 0 5.858000n 0 5.860000n 0 5.862000n 0 5.864000n 0 5.866000n 0 5.868000n 0 5.870000n 0 5.872000n 0 5.874000n 0 5.876000n 0 5.878000n 0 5.880000n 0 5.882000n 0 5.884000n 0 5.886000n 0 5.888000n 0 5.890000n 0 5.892000n 0 5.894000n 0 5.896000n 0 5.898000n 0 5.900000n 0 5.902000n 0 5.904000n 0 5.906000n 0 5.908000n 0 5.910000n 0 5.912000n 0 5.914000n 0 5.916000n 0 5.918000n 0 5.920000n 0 5.922000n 0 5.924000n 0 5.926000n 0 5.928000n 0 5.930000n 0 5.932000n 0 5.934000n 0 5.936000n 0 5.938000n 0 5.940000n 0 5.942000n 0 5.944000n 0 5.946000n 0 5.948000n 0 5.950000n 0 5.952000n 0 5.954000n 0 5.956000n 0 5.958000n 0 5.960000n 0 5.962000n 0 5.964000n 0 5.966000n 0 5.968000n 0 5.970000n 0 5.972000n 0 5.974000n 0 5.976000n 0 5.978000n 0 5.980000n 0 5.982000n 0 5.984000n 0 5.986000n 0 5.988000n 0 5.990000n 0 5.992000n 0 5.994000n 0.00126112025 5.996000n 0.00303544553 5.998000n 0.00480661861 6.000000n 0.00657464508 6.002000n 0.00833953054 6.004000n 0.0101012806 6.006000n 0.0118599007 6.008000n 0.0136153966 6.010000n 0.0153677737 6.012000n 0.0171170376 6.014000n 0.0188631938 6.016000n 0.0206062478 6.018000n 0.0223462052 6.020000n 0.0240830714 6.022000n 0.025816852 6.024000n 0.0275475524 6.026000n 0.0292751781 6.028000n 0.0309997346 6.030000n 0.0327212273 6.032000n 0.0344396616 6.034000n 0.0361550431 6.036000n 0.037867377 6.038000n 0.0395766688 6.040000n 0.041282924 6.042000n 0.042986148 6.044000n 0.044686346 6.046000n 0.0463835235 6.048000n 0.0480776859 6.050000n 0.0497688384 6.052000n 0.0514569866 6.054000n 0.0531421356 6.056000n 0.0548242909 6.058000n 0.0565034576 6.060000n 0.0581796413 6.062000n 0.0598528471 6.064000n 0.0615230803 6.066000n 0.0631903462 6.068000n 0.0648546502 6.070000n 0.0665159974 6.072000n 0.0681743931 6.074000n 0.0698298425 6.076000n 0.071482351 6.078000n 0.0731319236 6.080000n 0.0747785657 6.082000n 0.0764222824 6.084000n 0.078063079 6.086000n 0.0797009605 6.088000n 0.0813359323 6.090000n 0.0829679994 6.092000n 0.084597167 6.094000n 0.0862234403 6.096000n 0.0878468245 6.098000n 0.0894673246 6.100000n 0.0910849457 6.102000n 0.0926996931 6.104000n 0.0943115717 6.106000n 0.0959205868 6.108000n 0.0975267433 6.110000n 0.0991300463 6.112000n 0.100730501 6.114000n 0.102328112 6.116000n 0.103922886 6.118000n 0.105514825 6.120000n 0.107103937 6.122000n 0.108690226 6.124000n 0.110273696 6.126000n 0.111854353 6.128000n 0.113432203 6.130000n 0.115007249 6.132000n 0.116579496 6.134000n 0.118148951 6.136000n 0.119715617 6.138000n 0.1212795 6.140000n 0.122840605 6.142000n 0.124398936 6.144000n 0.125954499 6.146000n 0.127507299 6.148000n 0.129057339 6.150000n 0.130604626 6.152000n 0.132149164 6.154000n 0.133690958 6.156000n 0.135230013 6.158000n 0.136766334 6.160000n 0.138299925 6.162000n 0.139830792 6.164000n 0.141358939 6.166000n 0.142884372 6.168000n 0.144407094 6.170000n 0.145927111 6.172000n 0.147444428 6.174000n 0.148959049 6.176000n 0.150470979 6.178000n 0.151980223 6.180000n 0.153486786 6.182000n 0.154990672 6.184000n 0.156491887 6.186000n 0.157990435 6.188000n 0.15948632 6.190000n 0.160979548 6.192000n 0.162470123 6.194000n 0.16395805 6.196000n 0.165443333 6.198000n 0.166925978 6.200000n 0.168405989 6.202000n 0.16988337 6.204000n 0.171358127 6.206000n 0.172830264 6.208000n 0.174299785 6.210000n 0.175766696 6.212000n 0.177231 6.214000n 0.178692704 6.216000n 0.18015181 6.218000n 0.181608324 6.220000n 0.183062251 6.222000n 0.184513594 6.224000n 0.18596236 6.226000n 0.187408551 6.228000n 0.188852173 6.230000n 0.190293231 6.232000n 0.191731728 6.234000n 0.19316767 6.236000n 0.19460106 6.238000n 0.196031905 6.240000n 0.197460207 6.242000n 0.198885971 6.244000n 0.200309203 6.246000n 0.201729906 6.248000n 0.203148086 6.250000n 0.204563746 6.252000n 0.20597689 6.254000n 0.207387525 6.256000n 0.208795653 6.258000n 0.210201279 6.260000n 0.211604409 6.262000n 0.213005045 6.264000n 0.214403194 6.266000n 0.215798858 6.268000n 0.217192043 6.270000n 0.218582753 6.272000n 0.219970992 6.274000n 0.221356765 6.276000n 0.222740075 6.278000n 0.224120929 6.280000n 0.225499329 6.282000n 0.22687528 6.284000n 0.228248787 6.286000n 0.229619854 6.288000n 0.230988485 6.290000n 0.232354685 6.292000n 0.233718457 6.294000n 0.235079806 6.296000n 0.236438737 6.298000n 0.237795254 6.300000n 0.239149361 6.302000n 0.240501062 6.304000n 0.241850362 6.306000n 0.243197265 6.308000n 0.244541775 6.310000n 0.245883896 6.312000n 0.247223633 6.314000n 0.248560989 6.316000n 0.24989597 6.318000n 0.251228579 6.320000n 0.252558821 6.322000n 0.253886699 6.324000n 0.255212219 6.326000n 0.256535383 6.328000n 0.257856197 6.330000n 0.259174664 6.332000n 0.260490789 6.334000n 0.261804576 6.336000n 0.263116028 6.338000n 0.264425151 6.340000n 0.265731948 6.342000n 0.267036424 6.344000n 0.268338582 6.346000n 0.269638426 6.348000n 0.270935962 6.350000n 0.272231192 6.352000n 0.273524121 6.354000n 0.274814753 6.356000n 0.276103093 6.358000n 0.277389143 6.360000n 0.278672909 6.362000n 0.279954394 6.364000n 0.281233602 6.366000n 0.282510538 6.368000n 0.283785205 6.370000n 0.285057608 6.372000n 0.28632775 6.374000n 0.287595636 6.376000n 0.288861269 6.378000n 0.290124653 6.380000n 0.291385794 6.382000n 0.292644693 6.384000n 0.293901357 6.386000n 0.295155787 6.388000n 0.296407989 6.390000n 0.297657967 6.392000n 0.298905724 6.394000n 0.300151264 6.396000n 0.301394591 6.398000n 0.302635709 6.400000n 0.303874623 6.402000n 0.305111335 6.404000n 0.306345851 6.406000n 0.307578173 6.408000n 0.308808306 6.410000n 0.310036253 6.412000n 0.311262019 6.414000n 0.312485608 6.416000n 0.313707022 6.418000n 0.314926267 6.420000n 0.316143345 6.422000n 0.317358262 6.424000n 0.31857102 6.426000n 0.319781623 6.428000n 0.320990076 6.430000n 0.322196381 6.432000n 0.323400544 6.434000n 0.324602568 6.436000n 0.325802455 6.438000n 0.327000212 6.440000n 0.32819584 6.442000n 0.329389344 6.444000n 0.330580728 6.446000n 0.331769996 6.448000n 0.33295715 6.450000n 0.334142196 6.452000n 0.335325136 6.454000n 0.336505974 6.456000n 0.337684715 6.458000n 0.338861362 6.460000n 0.340035918 6.462000n 0.341208388 6.464000n 0.342378774 6.466000n 0.343547082 6.468000n 0.344713313 6.470000n 0.345877473 6.472000n 0.347039565 6.474000n 0.348199592 6.476000n 0.349357558 6.478000n 0.350513467 6.480000n 0.351667323 6.482000n 0.352819129 6.484000n 0.353968888 6.486000n 0.355116605 6.488000n 0.356262282 6.490000n 0.357405925 6.492000n 0.358547535 6.494000n 0.359687118 6.496000n 0.360824676 6.498000n 0.361960213 6.500000n 0.363093732 6.502000n 0.364225238 6.504000n 0.365354734 6.506000n 0.366482223 6.508000n 0.367607709 6.510000n 0.368731195 6.512000n 0.369852686 6.514000n 0.370972184 6.516000n 0.372089693 6.518000n 0.373205217 6.520000n 0.37431876 6.522000n 0.375430323 6.524000n 0.376539912 6.526000n 0.37764753 6.528000n 0.37875318 6.530000n 0.379856866 6.532000n 0.380958591 6.534000n 0.382058359 6.536000n 0.383156173 6.538000n 0.384252037 6.540000n 0.385345953 6.542000n 0.386437927 6.544000n 0.38752796 6.546000n 0.388616057 6.548000n 0.389702221 6.550000n 0.390786455 6.552000n 0.391868763 6.554000n 0.392949148 6.556000n 0.394027614 6.558000n 0.395104163 6.560000n 0.396178801 6.562000n 0.397251529 6.564000n 0.398322351 6.566000n 0.399391271 6.568000n 0.400458292 6.570000n 0.401523417 6.572000n 0.40258665 6.574000n 0.403647994 6.576000n 0.404707453 6.578000n 0.405765029 6.580000n 0.406820726 6.582000n 0.407874548 6.584000n 0.408926498 6.586000n 0.409976579 6.588000n 0.411024795 6.590000n 0.412071148 6.592000n 0.413115642 6.594000n 0.414158281 6.596000n 0.415199067 6.598000n 0.416238004 6.600000n 0.417275096 6.602000n 0.418310345 6.604000n 0.419343755 6.606000n 0.420375329 6.608000n 0.42140507 6.610000n 0.422432982 6.612000n 0.423459068 6.614000n 0.424483331 6.616000n 0.425505774 6.618000n 0.426526401 6.620000n 0.427545214 6.622000n 0.428562218 6.624000n 0.429577415 6.626000n 0.430590808 6.628000n 0.431602401 6.630000n 0.432612196 6.632000n 0.433620198 6.634000n 0.434626409 6.636000n 0.435630833 6.638000n 0.436633471 6.640000n 0.437634329 6.642000n 0.438633409 6.644000n 0.439630713 6.646000n 0.440626246 6.648000n 0.44162001 6.650000n 0.442612009 6.652000n 0.443602246 6.654000n 0.444590723 6.656000n 0.445577444 6.658000n 0.446562412 6.660000n 0.44754563 6.662000n 0.448527102 6.664000n 0.44950683 6.666000n 0.450484817 6.668000n 0.451461067 6.670000n 0.452435582 6.672000n 0.453408367 6.674000n 0.454379423 6.676000n 0.455348753 6.678000n 0.456316362 6.680000n 0.457282252 6.682000n 0.458246426 6.684000n 0.459208886 6.686000n 0.460169637 6.688000n 0.461128682 6.690000n 0.462086022 6.692000n 0.463041661 6.694000n 0.463995603 6.696000n 0.46494785 6.698000n 0.465898406 6.700000n 0.466847272 6.702000n 0.467794453 6.704000n 0.468739951 6.706000n 0.46968377 6.708000n 0.470625911 6.710000n 0.471566379 6.712000n 0.472505176 6.714000n 0.473442305 6.716000n 0.47437777 6.718000n 0.475311572 6.720000n 0.476243716 6.722000n 0.477174203 6.724000n 0.478103038 6.726000n 0.479030222 6.728000n 0.479955759 6.730000n 0.480879652 6.732000n 0.481801903 6.734000n 0.482722516 6.736000n 0.483641494 6.738000n 0.484558838 6.740000n 0.485474554 6.742000n 0.486388642 6.744000n 0.487301106 6.746000n 0.488211949 6.748000n 0.489121175 6.750000n 0.490028784 6.752000n 0.490934782 6.754000n 0.49183917 6.756000n 0.492741951 6.758000n 0.493643128 6.760000n 0.494542704 6.762000n 0.495440682 6.764000n 0.496337065 6.766000n 0.497231856 6.768000n 0.498125056 6.770000n 0.49901667 6.772000n 0.4999067 6.774000n 0.500795148 6.776000n 0.501682019 6.778000n 0.502567313 6.780000n 0.503451035 6.782000n 0.504333187 6.784000n 0.505213772 6.786000n 0.506092792 6.788000n 0.506970251 6.790000n 0.50784615 6.792000n 0.508720494 6.794000n 0.509593284 6.796000n 0.510464524 6.798000n 0.511334216 6.800000n 0.512202363 6.802000n 0.513068968 6.804000n 0.513934033 6.806000n 0.514797561 6.808000n 0.515659555 6.810000n 0.516520017 6.812000n 0.517378951 6.814000n 0.518236359 6.816000n 0.519092244 6.818000n 0.519946609 6.820000n 0.520799455 6.822000n 0.521650786 6.824000n 0.522500605 6.826000n 0.523348914 6.828000n 0.524195716 6.830000n 0.525041014 6.832000n 0.52588481 6.834000n 0.526727106 6.836000n 0.527567907 6.838000n 0.528407213 6.840000n 0.529245029 6.842000n 0.530081356 6.844000n 0.530916198 6.846000n 0.531749556 6.848000n 0.532581433 6.850000n 0.533411833 6.852000n 0.534240758 6.854000n 0.53506821 6.856000n 0.535894192 6.858000n 0.536718706 6.860000n 0.537541756 6.862000n 0.538363343 6.864000n 0.539183471 6.866000n 0.540002142 6.868000n 0.540819358 6.870000n 0.541635123 6.872000n 0.542449438 6.874000n 0.543262307 6.876000n 0.544073732 6.878000n 0.544883715 6.880000n 0.545692259 6.882000n 0.546499366 6.884000n 0.54730504 6.886000n 0.548109282 6.888000n 0.548912096 6.890000n 0.549713483 6.892000n 0.550513447 6.894000n 0.551311989 6.896000n 0.552109113 6.898000n 0.55290482 6.900000n 0.553699114 6.902000n 0.554491997 6.904000n 0.555283472 6.906000n 0.55607354 6.908000n 0.556862204 6.910000n 0.557649468 6.912000n 0.558435332 6.914000n 0.559219801 6.916000n 0.560002876 6.918000n 0.56078456 6.920000n 0.561564855 6.922000n 0.562343764 6.924000n 0.563121289 6.926000n 0.563897433 6.928000n 0.564672198 6.930000n 0.565445586 6.932000n 0.566217601 6.934000n 0.566988244 6.936000n 0.567757517 6.938000n 0.568525425 6.940000n 0.569291968 6.942000n 0.570057149 6.944000n 0.57082097 6.946000n 0.571583435 6.948000n 0.572344545 6.950000n 0.573104303 6.952000n 0.573862712 6.954000n 0.574619773 6.956000n 0.575375489 6.958000n 0.576129862 6.960000n 0.576882895 6.962000n 0.57763459 6.964000n 0.57838495 6.966000n 0.579133977 6.968000n 0.579881673 6.970000n 0.580628041 6.972000n 0.581373083 6.974000n 0.582116801 6.976000n 0.582859198 6.978000n 0.583600276 6.980000n 0.584340038 6.982000n 0.585078485 6.984000n 0.58581562 6.986000n 0.586551446 6.988000n 0.587285965 6.990000n 0.588019178 6.992000n 0.588751089 6.994000n 0.5894817 6.996000n 0.590211013 6.998000n 0.59093903 7.000000n 0.591665754 7.002000n 0.592391186 7.004000n 0.59311533 7.006000n 0.593838187 7.008000n 0.594559761 7.010000n 0.595280052 7.012000n 0.595999063 7.014000n 0.596716798 7.016000n 0.597433257 7.018000n 0.598148443 7.020000n 0.598862359 7.022000n 0.599575006 7.024000n 0.600286388 7.026000n 0.600996505 7.028000n 0.601705361 7.030000n 0.602412958 7.032000n 0.603119297 7.034000n 0.603824382 7.036000n 0.604528214 7.038000n 0.605230795 7.040000n 0.605932129 7.042000n 0.606632216 7.044000n 0.60733106 7.046000n 0.608028662 7.048000n 0.608725025 7.050000n 0.609420151 7.052000n 0.610114042 7.054000n 0.6108067 7.056000n 0.611498127 7.058000n 0.612188326 7.060000n 0.612877299 7.062000n 0.613565048 7.064000n 0.614251575 7.066000n 0.614936883 7.068000n 0.615620973 7.070000n 0.616303847 7.072000n 0.616985509 7.074000n 0.617665959 7.076000n 0.618345201 7.078000n 0.619023236 7.080000n 0.619700066 7.082000n 0.620375694 7.084000n 0.621050121 7.086000n 0.621723351 7.088000n 0.622395384 7.090000n 0.623066223 7.092000n 0.623735871 7.094000n 0.624404329 7.096000n 0.625071599 7.098000n 0.625737684 7.100000n 0.626402586 7.102000n 0.627066306 7.104000n 0.627728847 7.106000n 0.628390212 7.108000n 0.629050401 7.110000n 0.629709417 7.112000n 0.630367263 7.114000n 0.63102394 7.116000n 0.63167945 7.118000n 0.632333796 7.120000n 0.632986979 7.122000n 0.633639002 7.124000n 0.634289866 7.126000n 0.634939574 7.128000n 0.635588128 7.130000n 0.63623553 7.132000n 0.636881781 7.134000n 0.637526884 7.136000n 0.638170842 7.138000n 0.638813655 7.140000n 0.639455326 7.142000n 0.640095858 7.144000n 0.640735251 7.146000n 0.641373508 7.148000n 0.642010632 7.150000n 0.642646624 7.152000n 0.643281485 7.154000n 0.643915219 7.156000n 0.644547827 7.158000n 0.645179311 7.160000n 0.645809674 7.162000n 0.646438916 7.164000n 0.647067041 7.166000n 0.647694049 7.168000n 0.648319944 7.170000n 0.648944727 7.172000n 0.649568399 7.174000n 0.650190964 7.176000n 0.650812423 7.178000n 0.651432778 7.180000n 0.65205203 7.182000n 0.652670183 7.184000n 0.653287237 7.186000n 0.653903195 7.188000n 0.654518059 7.190000n 0.65513183 7.192000n 0.655744511 7.194000n 0.656356104 7.196000n 0.65696661 7.198000n 0.657576031 7.200000n 0.65818437 7.202000n 0.658791628 7.204000n 0.659397807 7.206000n 0.660002909 7.208000n 0.660606936 7.210000n 0.66120989 7.212000n 0.661811773 7.214000n 0.662412587 7.216000n 0.663012333 7.218000n 0.663611014 7.220000n 0.664208631 7.222000n 0.664805186 7.224000n 0.665400682 7.226000n 0.66599512 7.228000n 0.666588501 7.230000n 0.667180829 7.232000n 0.667772104 7.234000n 0.668362328 7.236000n 0.668951505 7.238000n 0.669539634 7.240000n 0.670126719 7.242000n 0.67071276 7.244000n 0.671297761 7.246000n 0.671881722 7.248000n 0.672464645 7.250000n 0.673046534 7.252000n 0.673627388 7.254000n 0.67420721 7.256000n 0.674786003 7.258000n 0.675363767 7.260000n 0.675940504 7.262000n 0.676516217 7.264000n 0.677090907 7.266000n 0.677664577 7.268000n 0.678237227 7.270000n 0.678808859 7.272000n 0.679379477 7.274000n 0.67994908 7.276000n 0.680517672 7.278000n 0.681085253 7.280000n 0.681651826 7.282000n 0.682217392 7.284000n 0.682781954 7.286000n 0.683345513 7.288000n 0.68390807 7.290000n 0.684469628 7.292000n 0.685030189 7.294000n 0.683037134 7.296000n 0.670971018 7.298000n 0.659118055 7.300000n 0.647474478 7.302000n 0.63603659 7.304000n 0.624800757 7.306000n 0.613763409 7.308000n 0.60292104 7.310000n 0.592270205 7.312000n 0.581807522 7.314000n 0.571529666 7.316000n 0.561433373 7.318000n 0.551515434 7.320000n 0.5417727 7.322000n 0.532202075 7.324000n 0.522800519 7.326000n 0.513565044 7.328000n 0.504492718 7.330000n 0.495580659 7.332000n 0.486826034 7.334000n 0.478226063 7.336000n 0.469778014 7.338000n 0.461479203 7.340000n 0.453326993 7.342000n 0.445318796 7.344000n 0.437452066 7.346000n 0.429724306 7.348000n 0.422133059 7.350000n 0.414675915 7.352000n 0.407350504 7.354000n 0.400154499 7.356000n 0.393085614 7.358000n 0.386141604 7.360000n 0.379320263 7.362000n 0.372619423 7.364000n 0.366036956 7.366000n 0.359570771 7.368000n 0.353218814 7.370000n 0.346979066 7.372000n 0.340849546 7.374000n 0.334828307 7.376000n 0.328913435 7.378000n 0.323103051 7.380000n 0.31739531 7.382000n 0.311788399 7.384000n 0.306280536 7.386000n 0.300869971 7.388000n 0.295554986 7.390000n 0.290333893 7.392000n 0.285205032 7.394000n 0.280166774 7.396000n 0.275217519 7.398000n 0.270355695 7.400000n 0.265579756 7.402000n 0.260888187 7.404000n 0.256279496 7.406000n 0.251752219 7.408000n 0.247304918 7.410000n 0.242936181 7.412000n 0.238644619 7.414000n 0.234428869 7.416000n 0.230287592 7.418000n 0.226219472 7.420000n 0.222223217 7.422000n 0.218297558 7.424000n 0.214441247 7.426000n 0.210653059 7.428000n 0.206931791 7.430000n 0.20327626 7.432000n 0.199685306 7.434000n 0.196157788 7.436000n 0.192692584 7.438000n 0.189288595 7.440000n 0.185944738 7.442000n 0.182659952 7.444000n 0.179433193 7.446000n 0.176263436 7.448000n 0.173149674 7.450000n 0.170090918 7.452000n 0.167086196 7.454000n 0.164134553 7.456000n 0.161235053 7.458000n 0.158386773 7.460000n 0.155588809 7.462000n 0.152840272 7.464000n 0.15014029 7.466000n 0.147488003 7.468000n 0.14488257 7.470000n 0.142323163 7.472000n 0.139808969 7.474000n 0.13733919 7.476000n 0.13491304 7.478000n 0.132529748 7.480000n 0.130188559 7.482000n 0.127888727 7.484000n 0.125629523 7.486000n 0.123410229 7.488000n 0.121230139 7.490000n 0.119088562 7.492000n 0.116984816 7.494000n 0.114918234 7.496000n 0.112888159 7.498000n 0.110893946 7.500000n 0.108934961 7.502000n 0.107010583 7.504000n 0.105120199 7.506000n 0.10326321 7.508000n 0.101439025 7.510000n 0.0996470655 7.512000n 0.0978867614 7.514000n 0.0961575537 7.516000n 0.0944588932 7.518000n 0.0927902402 7.520000n 0.0911510645 7.522000n 0.0895408456 7.524000n 0.0879590718 7.526000n 0.0864052406 7.528000n 0.0848788585 7.530000n 0.0833794405 7.532000n 0.0819065103 7.534000n 0.0804596 7.536000n 0.0790382499 7.538000n 0.0776420085 7.540000n 0.0762704323 7.542000n 0.0749230855 7.544000n 0.0735995401 7.546000n 0.0722993756 7.548000n 0.0710221791 7.550000n 0.0697675447 7.552000n 0.0685350739 7.554000n 0.0673243752 7.556000n 0.066135064 7.558000n 0.0649667624 7.560000n 0.0638190993 7.562000n 0.0626917101 7.564000n 0.0615842367 7.566000n 0.0604963273 7.568000n 0.0594276362 7.570000n 0.0583778239 7.572000n 0.057346557 7.574000n 0.0563335078 7.576000n 0.0553383545 7.578000n 0.0543607809 7.580000n 0.0534004766 7.582000n 0.0524571365 7.584000n 0.0515304608 7.586000n 0.0506201552 7.588000n 0.0497259305 7.590000n 0.0488475026 7.592000n 0.0479845925 7.594000n 0.047136926 7.596000n 0.0463042339 7.598000n 0.0454862517 7.600000n 0.0446827194 7.602000n 0.0438933818 7.604000n 0.0431179881 7.606000n 0.0423562921 7.608000n 0.0416080518 7.610000n 0.0408730294 7.612000n 0.0401509915 7.614000n 0.0394417086 7.616000n 0.0387449555 7.618000n 0.0380605108 7.620000n 0.0373881571 7.622000n 0.0367276808 7.624000n 0.036078872 7.626000n 0.0354415248 7.628000n 0.0348154365 7.630000n 0.0342004083 7.632000n 0.0335962448 7.634000n 0.0330027541 7.636000n 0.0324197476 7.638000n 0.0318470402 7.640000n 0.0312844498 7.642000n 0.0307317979 7.644000n 0.0301889087 7.646000n 0.0296556099 7.648000n 0.0291317321 7.650000n 0.0286171087 7.652000n 0.0281115764 7.654000n 0.0276149744 7.656000n 0.0271271452 7.658000n 0.0266479336 7.660000n 0.0261771875 7.662000n 0.0257147574 7.664000n 0.0252604962 7.666000n 0.0248142597 7.668000n 0.0243759062 7.670000n 0.0239452963 7.672000n 0.0235222934 7.674000n 0.0231067629 7.676000n 0.022698573 7.678000n 0.0222975939 7.680000n 0.0219036982 7.682000n 0.0215167609 7.684000n 0.0211366589 7.686000n 0.0207632717 7.688000n 0.0203964804 7.690000n 0.0200361687 7.692000n 0.019682222 7.694000n 0.0193345279 7.696000n 0.0189929759 7.698000n 0.0186574576 7.700000n 0.0183278664 7.702000n 0.0180040975 7.704000n 0.0176860481 7.706000n 0.0173736172 7.708000n 0.0170667055 7.710000n 0.0167652156 7.712000n 0.0164690515 7.714000n 0.0161781193 7.716000n 0.0158923266 7.718000n 0.0156115824 7.720000n 0.0153357978 7.722000n 0.0150648849 7.724000n 0.0147987579 7.726000n 0.0145373321 7.728000n 0.0142805245 7.730000n 0.0140282535 7.732000n 0.0137804389 7.734000n 0.0135370021 7.736000n 0.0132978657 7.738000n 0.0130629538 7.740000n 0.0128321916 7.742000n 0.012605506 7.744000n 0.0123828248 7.746000n 0.0121640774 7.748000n 0.0119491942 7.750000n 0.0117381071 7.752000n 0.0115307489 7.754000n 0.0113270537 7.756000n 0.0111269569 7.758000n 0.0109303949 7.760000n 0.0107373052 7.762000n 0.0105476266 7.764000n 0.0103612986 7.766000n 0.0101782623 7.768000n 0.00999845931 7.770000n 0.00982183265 7.772000n 0.00964832616 7.774000n 0.00947788473 7.776000n 0.00931045421 7.778000n 0.00914598143 7.780000n 0.00898441411 7.782000n 0.00882570095 7.784000n 0.00866979151 7.786000n 0.00851663628 7.788000n 0.00836618659 7.790000n 0.00821839466 7.792000n 0.00807321352 7.794000n 0.00793059707 7.796000n 0.00779049999 7.798000n 0.00765287779 7.800000n 0.00751768673 7.802000n 0.00738488387 7.804000n 0.00725442703 7.806000n 0.00712627476 7.808000n 0.00700038635 7.810000n 0.00687672181 7.812000n 0.00675524184 7.814000n 0.00663590787 7.816000n 0.00651868198 7.818000n 0.00640352693 7.820000n 0.00629040614 7.822000n 0.00617928368 7.824000n 0.00607012423 7.826000n 0.00596289313 7.828000n 0.00585755631 7.830000n 0.0057540803 7.832000n 0.00565243224 7.834000n 0.00555257983 7.836000n 0.00545449135 7.838000n 0.00535813564 7.840000n 0.00526348209 7.842000n 0.00517050064 7.844000n 0.00507916174 7.846000n 0.00498943637 7.848000n 0.00490129604 7.850000n 0.00481471274 7.852000n 0.00472965897 7.854000n 0.00464610771 7.856000n 0.00456403241 7.858000n 0.00448340701 7.860000n 0.00440420588 7.862000n 0.00432640387 7.864000n 0.00424997627 7.866000n 0.00417489879 7.868000n 0.00410114758 7.870000n 0.00402869921 7.872000n 0.00395753068 7.874000n 0.00388761936 7.876000n 0.00381894306 7.878000n 0.00375147994 7.880000n 0.00368520859 7.882000n 0.00362010795 7.884000n 0.00355615734 7.886000n 0.00349333644 7.888000n 0.00343162529 7.890000n 0.0033710043 7.892000n 0.0033114542 7.894000n 0.00325295608 7.896000n 0.00319549134 7.898000n 0.00313904175 7.900000n 0.00308358936 7.902000n 0.00302911655 7.904000n 0.00297560603 7.906000n 0.0029230408 7.908000n 0.00287140415 7.910000n 0.00282067968 7.912000n 0.00277085128 7.914000n 0.00272190311 7.916000n 0.00267381964 7.918000n 0.00262658557 7.920000n 0.00258018592 7.922000n 0.00253460593 7.924000n 0.00248983113 7.926000n 0.0024458473 7.928000n 0.00240264046 7.930000n 0.00236019688 7.932000n 0.00231850309 7.934000n 0.00227754583 7.936000n 0.0022373121 7.938000n 0.00219778911 7.940000n 0.00215896431 7.942000n 0.00212082537 7.944000n 0.00208336017 7.946000n 0.0020465568 7.948000n 0.00201040358 7.950000n 0.00197488902 7.952000n 0.00194000184 7.954000n 0.00190573095 7.956000n 0.00187206547 7.958000n 0.00183899471 7.960000n 0.00180650816 7.962000n 0.00177459549 7.964000n 0.00174324657 7.966000n 0.00171245144 7.968000n 0.00168220032 7.970000n 0.0016524836 7.972000n 0.00162329183 7.974000n 0.00159461575 7.976000n 0.00156644625 7.978000n 0.00153877437 7.980000n 0.00151159132 7.982000n 0.00148488847 7.984000n 0.00145865734 7.986000n 0.00143288959 7.988000n 0.00140757704 7.990000n 0.00138271165 7.992000n 0.00135828551 7.994000n 0.00133429087 7.996000n 0.0013107201 7.998000n 0.00128756572 8.000000n 0.00126482037 8.002000n 0.00124247683 8.004000n 0.00122052799 8.006000n 0.00119896689 8.008000n 0.00117778668 8.010000n 0.00115698062 8.012000n 0.00113654211 8.014000n 0.00111646465 8.016000n 0.00109674187 8.018000n 0.0010773675 8.020000n 0.00105833538 8.022000n 0.00103963947 8.024000n 0.00102127384 8.026000n 0.00100323264 8.028000n 0.000985510146 8.030000n 0.000968100727 8.032000n 0.000950998852 8.034000n 0.000934199088 8.036000n 0.000917696098 8.038000n 0.00090148464 8.040000n 0.000885559564 8.042000n 0.00086991581 8.044000n 0.000854548409 8.046000n 0.00083945248 8.048000n 0.000824623226 8.050000n 0.000810055936 8.052000n 0.000795745984 8.054000n 0.000781688822 8.056000n 0.000767879985 8.058000n 0.000754315087 8.060000n 0.000740989818 8.062000n 0.000727899945 8.064000n 0.00071504131 8.066000n 0.000702409828 8.068000n 0.000690001485 8.070000n 0.000677812341 8.072000n 0.000665838523 8.074000n 0.000654076227 8.076000n 0.000642521716 8.078000n 0.00063117132 8.080000n 0.000620021434 8.082000n 0.000609068515 8.084000n 0.000598309083 8.086000n 0.00058773972 8.088000n 0.00057735707 8.090000n 0.000567157833 8.092000n 0.00055713877 8.094000n 0.000547296697 8.096000n 0.000537628488 8.098000n 0.000528131072 8.100000n 0.000518801432 8.102000n 0.000509636603 8.104000n 0.000500633675 8.106000n 0.000491789786 8.108000n 0.000483102129 8.110000n 0.000474567942 8.112000n 0.000466184515 8.114000n 0.000457949184 8.116000n 0.000449859334 8.118000n 0.000441912394 8.120000n 0.00043410584 8.122000n 0.000426437192 8.124000n 0.000418904014 8.126000n 0.000411503911 8.128000n 0.000404234535 8.130000n 0.000397093575 8.132000n 0.000390078763 8.134000n 0.00038318787 8.136000n 0.000376418707 8.138000n 0.000369769125 8.140000n 0.00036323701 8.142000n 0.000356820287 8.144000n 0.000350516918 8.146000n 0.0003443249 8.148000n 0.000338242267 8.150000n 0.000332267086 8.152000n 0.000326397459 8.154000n 0.000320631521 8.156000n 0.000314967441 8.158000n 0.000309403419 8.160000n 0.000303937687 8.162000n 0.00029856851 8.164000n 0.000293294181 8.166000n 0.000288113026 8.168000n 0.000283023397 8.170000n 0.000278023679 8.172000n 0.000273112283 8.174000n 0.000268287648 8.176000n 0.000263548243 8.178000n 0.000258892561 8.180000n 0.000254319123 8.182000n 0.000249826477 8.184000n 0.000245413195 8.186000n 0.000241077876 8.188000n 0.000236819141 8.190000n 0.000232635639 8.192000n 0.00022852604 8.194000n 0.000224489039 8.196000n 0.000220523353 8.198000n 0.000216627722 8.200000n 0.00021280091 8.202000n 0.000209041699 8.204000n 0.000205348896 8.206000n 0.000201721328 8.208000n 0.000198157842 8.210000n 0.000194657307 8.212000n 0.00019121861 8.214000n 0.000187840659 8.216000n 0.000184522381 8.218000n 0.000181262722 8.220000n 0.000178060645 8.222000n 0.000174915135 8.224000n 0.000171825191 8.226000n 0.000168789832 8.228000n 0.000165808094 8.230000n 0.00016287903 8.232000n 0.000160001709 8.234000n 0.000157175216 8.236000n 0.000154398655 8.238000n 0.000151671143 8.240000n 0.000148991813 8.242000n 0.000146359815 8.244000n 0.000143774312 8.246000n 0.000141234483 8.248000n 0.000138739521 8.250000n 0.000136288633 8.252000n 0.000133881042 8.254000n 0.000131515981 8.256000n 0.0001291927 8.258000n 0.000126910461 8.260000n 0.000124668539 8.262000n 0.00012246622 8.264000n 0.000120302807 8.266000n 0.000118177611 8.268000n 0.000116089958 8.270000n 0.000114039184 8.272000n 0.000112024637 8.274000n 0.000110045678 8.276000n 0.000108101679 8.278000n 0.000106192021 8.280000n 0.000104316097 8.282000n 0.000102473313 8.284000n 0.000100663082 8.286000n 9.88848297e-05 8.288000n 9.71379908e-05 8.290000n 9.54220105e-05 8.292000n 9.37363436e-05 8.294000n 9.20804547e-05 8.296000n 9.04538177e-05 8.298000n 8.88559159e-05 8.300000n 8.72862416e-05 8.302000n 8.57442962e-05 8.304000n 8.422959e-05 8.306000n 8.27416415e-05 8.308000n 8.12799783e-05 8.310000n 7.98441359e-05 8.312000n 7.84336583e-05 8.314000n 7.70480972e-05 8.316000n 7.56870127e-05 8.318000n 7.43499722e-05 8.320000n 7.30365511e-05 8.322000n 7.1746332e-05 8.324000n 7.04789052e-05 8.326000n 6.9233868e-05 8.328000n 6.80108248e-05 8.330000n 6.68093872e-05 8.332000n 6.56291734e-05 8.334000n 6.44698086e-05 8.336000n 6.33309244e-05 8.338000n 6.2212159e-05 8.340000n 6.1113157e-05 8.342000n 6.00335694e-05 8.344000n 5.89730531e-05 8.346000n 5.79312712e-05 8.348000n 5.69078928e-05 8.350000n 5.59025928e-05 8.352000n 5.49150517e-05 8.354000n 5.3944956e-05 8.356000n 5.29919974e-05 8.358000n 5.20558732e-05 8.360000n 5.1136286e-05 8.362000n 5.02329437e-05 8.364000n 4.93455592e-05 8.366000n 4.84738507e-05 8.368000n 4.76175413e-05 8.370000n 4.6776359e-05 8.372000n 4.59500364e-05 8.374000n 4.51383112e-05 8.376000n 4.43409254e-05 8.378000n 4.35576257e-05 8.380000n 4.27881633e-05 8.382000n 4.20322938e-05 8.384000n 4.1289777e-05 8.386000n 4.05603771e-05 8.388000n 3.98438623e-05 8.390000n 3.9140005e-05 8.392000n 3.84485816e-05 8.394000n 3.77693725e-05 8.396000n 3.71021618e-05 8.398000n 3.64467377e-05 8.400000n 3.5802892e-05 8.402000n 3.517042e-05 8.404000n 3.45491208e-05 8.406000n 3.39387972e-05 8.408000n 3.33392552e-05 8.410000n 3.27503043e-05 8.412000n 3.21717574e-05 8.414000n 3.16034308e-05 8.416000n 3.1045144e-05 8.418000n 3.04967194e-05 8.420000n 2.9957983e-05 8.422000n 2.94287636e-05 8.424000n 2.89088931e-05 8.426000n 2.83982063e-05 8.428000n 2.78965409e-05 8.430000n 2.74037377e-05 8.432000n 2.691964e-05 8.434000n 2.64440941e-05 8.436000n 2.5976949e-05 8.438000n 2.55180561e-05 8.440000n 2.50672697e-05 8.442000n 2.46244466e-05 8.444000n 2.41894462e-05 8.446000n 2.37621303e-05 8.448000n 2.3342363e-05 8.450000n 2.29300111e-05 8.452000n 2.25249435e-05 8.454000n 2.21270317e-05 8.456000n 2.17361491e-05 8.458000n 2.13521715e-05 8.460000n 2.09749771e-05 8.462000n 2.0604446e-05 8.464000n 2.02404605e-05 8.466000n 1.98829049e-05 8.468000n 1.95316657e-05 8.470000n 1.91866312e-05 8.472000n 1.88476919e-05 8.474000n 1.85147401e-05 8.476000n 1.818767e-05 8.478000n 1.78663778e-05 8.480000n 1.75507613e-05 8.482000n 1.72407203e-05 8.484000n 1.69361562e-05 8.486000n 1.66369725e-05 8.488000n 1.63430739e-05 8.490000n 1.60543671e-05 8.492000n 1.57707605e-05 8.494000n 1.54921639e-05 8.496000n 1.52184888e-05 8.498000n 1.49496483e-05 8.500000n 1.4685557e-05 8.502000n 1.44261309e-05 8.504000n 1.41712877e-05 8.506000n 1.39209464e-05 8.508000n 1.36750275e-05 8.510000n 1.34334528e-05 8.512000n 1.31961456e-05 8.514000n 1.29630306e-05 8.516000n 1.27340336e-05 8.518000n 1.2509082e-05 8.520000n 1.22881042e-05 8.522000n 1.207103e-05 8.524000n 1.18577906e-05 8.526000n 1.16483181e-05 8.528000n 1.14425461e-05 8.530000n 1.12404091e-05 8.532000n 1.10418429e-05 8.534000n 1.08467844e-05 8.536000n 1.06551718e-05 8.538000n 1.0466944e-05 8.540000n 1.02820414e-05 8.542000n 1.01004051e-05 8.544000n 9.92197755e-06 8.546000n 9.74670196e-06 8.548000n 9.57452269e-06 8.550000n 9.40538503e-06 8.552000n 9.23923525e-06 8.554000n 9.07602057e-06 8.556000n 8.91568914e-06 8.558000n 8.75819003e-06 8.560000n 8.6034732e-06 8.562000n 8.45148951e-06 8.564000n 8.30219066e-06 8.566000n 8.15552924e-06 8.568000n 8.01145865e-06 8.570000n 7.86993312e-06 8.572000n 7.73090769e-06 8.574000n 7.59433821e-06 8.576000n 7.46018127e-06 8.578000n 7.32839427e-06 8.580000n 7.19893534e-06 8.582000n 7.07176336e-06 8.584000n 6.94683791e-06 8.586000n 6.82411932e-06 8.588000n 6.7035686e-06 8.590000n 6.58514746e-06 8.592000n 6.46881827e-06 8.594000n 6.35454408e-06 8.596000n 6.2422886e-06 8.598000n 6.13201614e-06 8.600000n 6.0236917e-06 8.602000n 5.91728084e-06 8.604000n 5.81274978e-06 8.606000n 5.7100653e-06 8.608000n 5.60919478e-06 8.610000n 5.51010617e-06 8.612000n 5.41276801e-06 8.614000n 5.31714936e-06 8.616000n 5.22321985e-06 8.618000n 5.13094964e-06 8.620000n 5.04030942e-06 8.622000n 4.9512704e-06 8.624000n 4.86380429e-06 8.626000n 4.7778833e-06 8.628000n 4.69348013e-06 8.630000n 4.61056798e-06 8.632000n 4.52912051e-06 8.634000n 4.44911184e-06 8.636000n 4.37051655e-06 8.638000n 4.29330967e-06 8.640000n 4.21746669e-06 8.642000n 4.14296351e-06 8.644000n 4.06977645e-06 8.646000n 3.99788226e-06 8.648000n 3.92725812e-06 8.650000n 3.85788158e-06 8.652000n 3.78973061e-06 8.654000n 3.72278354e-06 8.656000n 3.65701913e-06 8.658000n 3.59241646e-06 8.660000n 3.52895503e-06 8.662000n 3.46661467e-06 8.664000n 3.40537558e-06 8.666000n 3.34521829e-06 8.668000n 3.28612371e-06 8.670000n 3.22807306e-06 8.672000n 3.1710479e-06 8.674000n 3.1150301e-06 8.676000n 3.06000189e-06 8.678000n 3.00594577e-06 8.680000n 2.95284457e-06 8.682000n 2.90068142e-06 8.684000n 2.84943976e-06 8.686000n 2.7991033e-06 8.688000n 2.74965605e-06 8.690000n 2.70108231e-06 8.692000n 2.65336664e-06 8.694000n 2.60649389e-06 8.696000n 2.56044916e-06 8.698000n 2.51521783e-06 8.700000n 2.47078553e-06 8.702000n 2.42713815e-06 8.704000n 2.38426181e-06 8.706000n 2.3421429e-06 8.708000n 2.30076803e-06 8.710000n 2.26012407e-06 8.712000n 2.2201981e-06 8.714000n 2.18097744e-06 8.716000n 2.14244963e-06 8.718000n 2.10460242e-06 8.720000n 2.06742381e-06 8.722000n 2.03090196e-06 8.724000n 1.99502529e-06 8.726000n 1.95978239e-06 8.728000n 1.92516208e-06 8.730000n 1.89115334e-06 8.732000n 1.85774538e-06 8.734000n 1.82492759e-06 8.736000n 1.79268953e-06 8.738000n 1.76102098e-06 8.740000n 1.72991186e-06 8.742000n 1.69935229e-06 8.744000n 1.66933257e-06 8.746000n 1.63984317e-06 8.748000n 1.6108747e-06 8.750000n 1.58241797e-06 8.752000n 1.55446394e-06 8.754000n 1.52700374e-06 8.756000n 1.50002862e-06 8.758000n 1.47353003e-06 8.760000n 1.44749955e-06 8.762000n 1.42192891e-06 8.764000n 1.39680998e-06 8.766000n 1.37213479e-06 8.768000n 1.3478955e-06 8.770000n 1.3240844e-06 8.772000n 1.30069394e-06 8.774000n 1.27771667e-06 8.776000n 1.25514531e-06 8.778000n 1.23297268e-06 8.780000n 1.21119174e-06 8.782000n 1.18979557e-06 8.784000n 1.16877737e-06 8.786000n 1.14813046e-06 8.788000n 1.12784829e-06 8.790000n 1.10792441e-06 8.792000n 1.0883525e-06 8.794000n 1.06912633e-06 8.796000n 1.0502398e-06 8.798000n 1.0316869e-06 8.800000n 1.01346175e-06 8.802000n 9.95558558e-07 8.804000n 9.7797163e-07 8.806000n 9.60695381e-07 8.808000n 9.43724324e-07 8.810000n 9.27053067e-07 8.812000n 9.10676315e-07 8.814000n 8.94588864e-07 8.816000n 8.78785604e-07 8.818000n 8.63261515e-07 8.820000n 8.48011665e-07 8.822000n 8.3303121e-07 8.824000n 8.1831539e-07 8.826000n 8.03859531e-07 8.828000n 7.8965904e-07 8.830000n 7.75709407e-07 8.832000n 7.62006199e-07 8.834000n 7.48545063e-07 8.836000n 7.35321724e-07 8.838000n 7.2233198e-07 8.840000n 7.09571705e-07 8.842000n 6.97036846e-07 8.844000n 6.84723419e-07 8.846000n 6.72627514e-07 8.848000n 6.60745288e-07 8.850000n 6.49072965e-07 8.852000n 6.37606839e-07 8.854000n 6.26343267e-07 8.856000n 6.1527867e-07 8.858000n 6.04409533e-07 8.860000n 5.93732404e-07 8.862000n 5.83243891e-07 8.864000n 5.72940661e-07 8.866000n 5.62819442e-07 8.868000n 5.52877018e-07 8.870000n 5.4311023e-07 8.872000n 5.33515977e-07 8.874000n 5.2409121e-07 8.876000n 5.14832936e-07 8.878000n 5.05738212e-07 8.880000n 4.9680415e-07 8.882000n 4.88027912e-07 8.884000n 4.79406709e-07 8.886000n 4.70937803e-07 8.888000n 4.62618504e-07 8.890000n 4.54446169e-07 8.892000n 4.46418201e-07 8.894000n 4.3853205e-07 8.896000n 4.30785211e-07 8.898000n 4.23175223e-07 8.900000n 4.15699668e-07 8.902000n 4.08356172e-07 8.904000n 4.01142402e-07 8.906000n 3.94056065e-07 8.908000n 3.87094912e-07 8.910000n 3.8025673e-07 8.912000n 3.73539347e-07 8.914000n 3.66940629e-07 8.916000n 3.60458481e-07 8.918000n 3.54090842e-07 8.920000n 3.47835689e-07 8.922000n 3.41691037e-07 8.924000n 3.35654932e-07 8.926000n 3.29725457e-07 8.928000n 3.23900729e-07 8.930000n 3.18178897e-07 8.932000n 3.12558143e-07 8.934000n 3.07036682e-07 8.936000n 3.0161276e-07 8.938000n 2.96284653e-07 8.940000n 2.9105067e-07 8.942000n 2.85909147e-07 8.944000n 2.80858451e-07 8.946000n 2.75896977e-07 8.948000n 2.7102315e-07 8.950000n 2.66235421e-07 8.952000n 2.61532269e-07 8.954000n 2.569122e-07 8.956000n 2.52373746e-07 8.958000n 2.47915465e-07 8.960000n 2.43535943e-07 8.962000n 2.39233786e-07 8.964000n 2.35007628e-07 8.966000n 2.30856127e-07 8.968000n 2.26777964e-07 8.970000n 2.22771843e-07 8.972000n 2.18836492e-07 8.974000n 2.1497066e-07 8.976000n 2.1117312e-07 8.978000n 2.07442665e-07 8.980000n 2.03778109e-07 8.982000n 2.0017829e-07 8.984000n 1.96642063e-07 8.986000n 1.93168304e-07 8.988000n 1.89755911e-07 8.990000n 1.86403799e-07 8.992000n 1.83110904e-07 8.994000n 1.79876179e-07 8.996000n 1.76698596e-07 8.998000n 1.73577147e-07 9.000000n 1.70510839e-07 9.002000n 1.67498699e-07 9.004000n 1.64539769e-07 9.006000n 1.6163311e-07 9.008000n 1.58777799e-07 9.010000n 1.55972927e-07 9.012000n 1.53217605e-07 9.014000n 1.50510956e-07 9.016000n 1.47852122e-07 9.018000n 1.45240257e-07 9.020000n 1.42674531e-07 9.022000n 1.4015413e-07 9.024000n 1.37678253e-07 9.026000n 1.35246113e-07 9.028000n 1.32856938e-07 9.030000n 1.30509969e-07 9.032000n 1.28204459e-07 9.034000n 1.25939678e-07 9.036000n 1.23714905e-07 9.038000n 1.21529433e-07 9.040000n 1.19382568e-07 9.042000n 1.17273629e-07 9.044000n 1.15201945e-07 9.046000n 1.13166857e-07 9.048000n 1.11167721e-07 9.050000n 1.092039e-07 9.052000n 1.07274771e-07 9.054000n 1.0537972e-07 9.056000n 1.03518146e-07 9.058000n 1.01689458e-07 9.060000n 9.98930745e-08 9.062000n 9.81284246e-08 9.064000n 9.63949478e-08 9.066000n 9.46920936e-08 9.068000n 9.3019321e-08 9.070000n 9.13760986e-08 9.072000n 8.97619044e-08 9.074000n 8.81762254e-08 9.076000n 8.66185582e-08 9.078000n 8.50884077e-08 9.080000n 8.35852879e-08 9.082000n 8.21087214e-08 9.084000n 8.06582389e-08 9.086000n 7.92333797e-08 9.088000n 7.78336914e-08 9.090000n 7.6458729e-08 9.092000n 7.51080559e-08 9.094000n 7.37812429e-08 9.096000n 7.24778686e-08 9.098000n 7.11975189e-08 9.100000n 6.99397871e-08 9.102000n 6.87042736e-08 9.104000n 6.74905859e-08 9.106000n 6.62983385e-08 9.108000n 6.51271526e-08 9.110000n 6.39766561e-08 9.112000n 6.28464837e-08 9.114000n 6.17362761e-08 9.116000n 6.06456808e-08 9.118000n 5.95743513e-08 9.120000n 5.85219473e-08 9.122000n 5.74881344e-08 9.124000n 5.64725842e-08 9.126000n 5.54749739e-08 9.128000n 5.44949871e-08 9.130000n 5.35323119e-08 9.132000n 5.25866428e-08 9.134000n 5.16576794e-08 9.136000n 5.07451264e-08 9.138000n 4.98486941e-08 9.140000n 4.89680975e-08 9.142000n 4.81030571e-08 9.144000n 4.72532978e-08 9.146000n 4.641855e-08 9.148000n 4.55985483e-08 9.150000n 4.47930322e-08 9.152000n 4.40017459e-08 9.154000n 4.3224438e-08 9.156000n 4.24608615e-08 9.158000n 4.17107739e-08 9.160000n 4.09739369e-08 9.162000n 4.02501164e-08 9.164000n 3.95390825e-08 9.166000n 3.88406092e-08 9.168000n 3.81544747e-08 9.170000n 3.74804612e-08 9.172000n 3.68183543e-08 9.174000n 3.61679438e-08 9.176000n 3.55290229e-08 9.178000n 3.49013889e-08 9.180000n 3.42848423e-08 9.182000n 3.36791873e-08 9.184000n 3.30842314e-08 9.186000n 3.24997855e-08 9.188000n 3.19256642e-08 9.190000n 3.1361685e-08 9.192000n 3.08076686e-08 9.194000n 3.02634392e-08 9.196000n 2.97288238e-08 9.198000n 2.92036526e-08 9.200000n 2.86877587e-08 9.202000n 2.81809783e-08 9.204000n 2.76831504e-08 9.206000n 2.71941168e-08 9.208000n 2.67137221e-08 9.210000n 2.62418138e-08 9.212000n 2.57782421e-08 9.214000n 2.53228594e-08 9.216000n 2.48755212e-08 9.218000n 2.44360855e-08 9.220000n 2.40044126e-08 9.222000n 2.35803653e-08 9.224000n 2.3163809e-08 9.226000n 2.27546113e-08 9.228000n 2.23526423e-08 9.230000n 2.19577742e-08 9.232000n 2.15698815e-08 9.234000n 2.11888412e-08 9.236000n 2.08145321e-08 9.238000n 2.04468353e-08 9.240000n 2.0085634e-08 9.242000n 1.97308135e-08 9.244000n 1.9382261e-08 9.246000n 1.90398658e-08 9.248000n 1.87035192e-08 9.250000n 1.83731143e-08 9.252000n 1.80485461e-08 9.254000n 1.77297115e-08 9.256000n 1.74165092e-08 9.258000n 1.71088399e-08 9.260000n 1.68066056e-08 9.262000n 1.65097104e-08 9.264000n 1.62180599e-08 9.266000n 1.59315616e-08 9.268000n 1.56501244e-08 9.270000n 1.53736588e-08 9.272000n 1.51020771e-08 9.274000n 1.48352931e-08 9.276000n 1.4573222e-08 9.278000n 1.43157803e-08 9.280000n 1.40628865e-08 9.282000n 1.38144601e-08 9.284000n 1.35704223e-08 9.286000n 1.33306955e-08 9.288000n 1.30952036e-08 9.290000n 1.28638717e-08 9.292000n 1.26366265e-08 9.294000n 1.24133955e-08 9.296000n 1.21941081e-08 9.298000n 1.19786945e-08 9.300000n 1.17670862e-08 9.302000n 1.1559216e-08 9.304000n 1.13550179e-08 9.306000n 1.11544272e-08 9.308000n 1.09573799e-08 9.310000n 1.07638135e-08 9.312000n 1.05736666e-08 9.314000n 1.03868787e-08 9.316000n 1.02033904e-08 9.318000n 1.00231435e-08 9.320000n 9.84608084e-09 9.322000n 9.67214597e-09 9.324000n 9.50128376e-09 9.326000n 9.33343991e-09 9.328000n 9.16856102e-09 9.330000n 9.00659491e-09 9.332000n 8.84748985e-09 9.334000n 8.69119554e-09 9.336000n 8.53766213e-09 9.338000n 8.38684111e-09 9.340000n 8.23868429e-09 9.342000n 8.09314471e-09 9.344000n 7.95017618e-09 9.346000n 7.80973319e-09 9.348000n 7.67177122e-09 9.350000n 7.5362464e-09 9.352000n 7.40311568e-09 9.354000n 7.27233673e-09 9.356000n 7.14386816e-09 9.358000n 7.01766889e-09 9.360000n 6.89369906e-09 9.362000n 6.77191925e-09 9.364000n 6.65229061e-09 9.366000n 6.53477528e-09 9.368000n 6.41933595e-09 9.370000n 6.30593588e-09 9.372000n 6.1945391e-09 9.374000n 6.08511019e-09 9.376000n 5.97761429e-09 9.378000n 5.87201743e-09 9.380000n 5.76828596e-09 9.382000n 5.66638703e-09 9.384000n 5.5662881e-09 9.386000n 5.46795742e-09 9.388000n 5.3713638e-09 9.390000n 5.27647659e-09 9.392000n 5.18326559e-09 9.394000n 5.09170117e-09 9.396000n 5.00175434e-09 9.398000n 4.91339636e-09 9.400000n 4.82659934e-09 9.402000n 4.74133555e-09 9.404000n 4.65757799e-09 9.406000n 4.57530014e-09 9.408000n 4.49447568e-09 9.410000n 4.41507897e-09 9.412000n 4.33708491e-09 9.414000n 4.26046864e-09 9.416000n 4.18520574e-09 9.418000n 4.11127254e-09 9.420000n 4.03864531e-09 9.422000n 3.96730104e-09 9.424000n 3.8972171e-09 9.426000n 3.82837129e-09 9.428000n 3.76074161e-09 9.430000n 3.69430664e-09 9.432000n 3.62904529e-09 9.434000n 3.56493679e-09 9.436000n 3.50196083e-09 9.438000n 3.44009732e-09 9.440000n 3.3793266e-09 9.442000n 3.31962957e-09 9.444000n 3.26098704e-09 9.446000n 3.20338034e-09 9.448000n 3.14679138e-09 9.450000n 3.09120218e-09 9.452000n 3.03659486e-09 9.454000n 2.98295222e-09 9.456000n 2.93025726e-09 9.458000n 2.87849311e-09 9.460000n 2.82764334e-09 9.462000n 2.77769197e-09 9.464000n 2.72862299e-09 9.466000n 2.68042077e-09 9.468000n 2.6330701e-09 9.470000n 2.58655586e-09 9.472000n 2.54086341e-09 9.474000n 2.49597809e-09 9.476000n 2.45188558e-09 9.478000n 2.40857212e-09 9.480000n 2.36602371e-09 9.482000n 2.32422703e-09 9.484000n 2.28316865e-09 9.486000n 2.24283558e-09 9.488000n 2.20321505e-09 9.490000n 2.16429441e-09 9.492000n 2.12606122e-09 9.494000n 2.08850359e-09 9.496000n 2.05160933e-09 9.498000n 2.01536687e-09 9.500000n 1.97976469e-09 9.502000n 1.94479133e-09 9.504000n 1.91043581e-09 9.506000n 1.87668725e-09 9.508000n 1.84353488e-09 9.510000n 1.81096804e-09 9.512000n 1.77897663e-09 9.514000n 1.74755033e-09 9.516000n 1.71667913e-09 9.518000n 1.68635339e-09 9.520000n 1.65656322e-09 9.522000n 1.62729941e-09 9.524000n 1.59855251e-09 9.526000n 1.57031355e-09 9.528000n 1.54257329e-09 9.530000n 1.51532309e-09 9.532000n 1.48855439e-09 9.534000n 1.46225843e-09 9.536000n 1.43642709e-09 9.538000n 1.41105205e-09 9.540000n 1.38612533e-09 9.542000n 1.3616388e-09 9.544000n 1.33758493e-09 9.546000n 1.31395606e-09 9.548000n 1.29074451e-09 9.550000n 1.26794297e-09 9.552000n 1.24554422e-09 9.554000n 1.22354127e-09 9.556000n 1.20192689e-09 9.558000n 1.18069443e-09 9.560000n 1.159837e-09 9.562000n 1.13934795e-09 9.564000n 1.11922094e-09 9.566000n 1.09944953e-09 9.568000n 1.08002729e-09 9.570000n 1.06094822e-09 9.572000n 1.0422061e-09 9.574000n 1.02379516e-09 9.576000n 1.0057094e-09 9.578000n 9.87943172e-10 9.580000n 9.70490799e-10 9.582000n 9.53346735e-10 9.584000n 9.36505429e-10 9.586000n 9.19961662e-10 9.588000n 9.03710218e-10 9.590000n 8.87745877e-10 9.592000n 8.72063421e-10 9.594000n 8.56658078e-10 9.596000n 8.41524961e-10 9.598000n 8.26659075e-10 9.600000n 8.12055756e-10 9.602000n 7.97710564e-10 9.604000n 7.83618614e-10 9.606000n 7.69775688e-10 9.608000n 7.56177343e-10 9.610000n 7.4281914e-10 9.612000n 7.2969697e-10 9.614000n 7.16806614e-10 9.616000n 7.04143965e-10 9.618000n 6.91704916e-10 9.620000n 6.7948569e-10 9.622000n 6.67482403e-10 9.624000n 6.55691057e-10 9.626000n 6.44107989e-10 9.628000n 6.32729535e-10 9.630000n 6.21552143e-10 9.632000n 6.10572148e-10 9.634000n 5.99786221e-10 9.636000n 5.89190696e-10 9.638000n 5.78782466e-10 9.640000n 5.68558089e-10 9.642000n 5.58514235e-10 9.644000n 5.48647905e-10 9.646000n 5.38955769e-10 9.648000n 5.2943494e-10 9.650000n 5.200822e-10 9.652000n 5.10894771e-10 9.654000n 5.01869657e-10 9.656000n 4.93003971e-10 9.658000n 4.84294826e-10 9.660000n 4.75739559e-10 9.662000n 4.67335393e-10 9.664000n 4.59079774e-10 9.666000n 4.50969928e-10 9.668000n 4.43003412e-10 9.670000n 4.35177561e-10 9.672000n 4.27489932e-10 9.674000n 4.19938195e-10 9.676000n 4.12519796e-10 9.678000n 4.05232514e-10 9.680000n 3.98073907e-10 9.682000n 3.91041755e-10 9.684000n 3.84133836e-10 9.686000n 3.77348042e-10 9.688000n 3.70682041e-10 9.690000n 3.64133723e-10 9.692000n 3.57701202e-10 9.694000n 3.51382257e-10 9.696000n 3.45175e-10 9.698000n 3.39077322e-10 9.700000n 3.33087335e-10 9.702000n 3.27203264e-10 9.704000n 3.2142311e-10 9.706000n 3.15744986e-10 9.708000n 3.10167225e-10 9.710000n 3.04688053e-10 9.712000n 2.9930558e-10 9.714000n 2.94018254e-10 9.716000n 2.88824298e-10 9.718000n 2.83722157e-10 9.720000n 2.78710055e-10 9.722000n 2.73786549e-10 9.724000n 2.68949973e-10 9.726000n 2.64198885e-10 9.728000n 2.59531729e-10 9.730000n 2.54946952e-10 9.732000n 2.50443222e-10 9.734000n 2.46019094e-10 9.736000n 2.41673015e-10 9.738000n 2.37403763e-10 9.740000n 2.33210007e-10 9.742000n 2.29090191e-10 9.744000n 2.25043206e-10 9.746000n 2.21067831e-10 9.748000n 2.1716251e-10 9.750000n 2.13326246e-10 9.752000n 2.09557816e-10 9.754000n 2.05855888e-10 9.756000n 2.02219352e-10 9.758000n 1.98647099e-10 9.760000n 1.95137906e-10 9.762000n 1.91690663e-10 9.764000n 1.88304372e-10 9.766000n 1.84977922e-10 9.768000n 1.81710202e-10 9.770000n 1.78500215e-10 9.772000n 1.75346959e-10 9.774000n 1.72249437e-10 9.776000n 1.69206538e-10 9.778000n 1.66217484e-10 9.780000n 1.63281166e-10 9.782000n 1.60396696e-10 9.784000n 1.57563296e-10 9.786000n 1.54779856e-10 9.788000n 1.52045598e-10 9.790000n 1.49359636e-10 9.792000n 1.46721191e-10 9.794000n 1.44129264e-10 9.796000n 1.4158319e-10 9.798000n 1.39082079e-10 9.800000n 1.36625156e-10 9.802000n 1.34211531e-10 9.804000n 1.3184065e-10 9.806000n 1.29511624e-10 9.808000n 1.27223787e-10 9.810000n 1.24976363e-10 9.812000n 1.22768573e-10 9.814000n 1.20599863e-10 9.816000n 1.18469345e-10 9.818000n 1.16376575e-10 9.820000n 1.14320775e-10 9.822000n 1.12301168e-10 9.824000n 1.10317311e-10 9.826000n 1.08368536e-10 9.828000n 1.06454179e-10 9.830000n 1.04573683e-10 9.832000n 1.02726272e-10 9.834000n 1.00911612e-10 9.836000n 9.91289273e-11 9.838000n 9.73777725e-11 9.840000n 9.5657593e-11 9.842000n 9.39677225e-11 9.844000n 9.2307828e-11 9.846000n 9.06771325e-11 9.848000n 8.90753027e-11 9.850000n 8.75017836e-11 9.852000n 8.59560201e-11 9.854000n 8.4437568e-11 9.856000n 8.29458724e-11 9.858000n 8.14806e-11 9.860000n 8.00413069e-11 9.862000n 7.86273269e-11 9.864000n 7.72383268e-11 9.866000n 7.58738627e-11 9.868000n 7.45334905e-11 9.870000n 7.3216877e-11 9.872000n 7.19234672e-11 9.874000n 7.0652928e-11 9.876000n 6.94048152e-11 9.878000n 6.81786849e-11 9.880000n 6.6974315e-11 9.882000n 6.57911503e-11 9.884000n 6.46289688e-11 9.886000n 6.34873265e-11 9.888000n 6.23657792e-11 9.890000n 6.12639939e-11 9.892000n 6.01817485e-11 9.894000n 5.91185989e-11 9.896000n 5.80743231e-11 9.898000n 5.7048366e-11 9.900000n 5.60406166e-11 9.902000n 5.50506307e-11 9.904000n 5.40781864e-11 9.906000n 5.31228395e-11 9.908000n 5.21843679e-11 9.910000n 5.12625498e-11 9.912000n 5.03569408e-11 9.914000n 4.94674302e-11 9.916000n 4.85935736e-11 9.918000n 4.77351492e-11 9.920000n 4.68918238e-11 9.922000n 4.60634864e-11 9.924000n 4.52498039e-11 9.926000n 4.44504433e-11 9.928000n 4.36651826e-11 9.930000n 4.28937996e-11 9.932000n 4.21360724e-11 9.934000n 4.13916679e-11 9.936000n 4.0660475e-11 9.938000n 3.99422717e-11 9.940000n 3.9236614e-11 9.942000n 3.85435017e-11 9.944000n 3.78626019e-11 9.946000n 3.71938036e-11 9.948000n 3.65366626e-11 9.950000n 3.58912899e-11 9.952000n 3.52572416e-11 9.954000n 3.46344065e-11 9.956000n 3.40225625e-11 9.958000n 3.34215988e-11 9.960000n 3.28311822e-11 9.962000n 3.22512017e-11 9.964000n 3.16814353e-11 9.966000n 3.11217718e-11 9.968000n 3.05719894e-11 9.970000n 3.00319769e-11 9.972000n 2.95014013e-11 9.974000n 2.89802626e-11 9.976000n 2.84683388e-11 9.978000n 2.79654078e-11 9.980000n 2.74713585e-11 9.982000n 2.698608e-11 9.984000n 2.65093503e-11 9.986000n 2.60410582e-11 9.988000n 2.55810928e-11 9.990000n 2.5129121e-11 9.992000n 2.46852538e-11 9.994000n 2.42491582e-11 9.996000n 2.38208342e-11 9.998000n 2.33999486e-11 10.000000n 2.29866126e-11 10.002000n 2.25806041e-11 10.004000n 2.21817009e-11 10.006000n 2.17897922e-11 10.008000n 2.14048779e-11 10.010000n 2.10267359e-11 10.012000n 2.06553663e-11 10.014000n 2.0290436e-11 10.016000n 1.9931945e-11 10.018000n 1.95798933e-11 10.020000n 1.92339478e-11 10.022000n 1.88942195e-11 10.024000n 1.85604865e-11 10.026000n 1.82325266e-11 10.028000n 1.79104509e-11 10.030000n 1.75940373e-11 10.032000n 1.72832859e-11 10.034000n 1.69779746e-11 10.036000n 1.66779923e-11 10.038000n 1.63834502e-11 10.040000n 1.6094015e-11 10.042000n 1.58096869e-11 10.044000n 1.55304658e-11 10.046000n 1.52560187e-11 10.048000n 1.49865675e-11 10.050000n 1.47217794e-11 10.052000n 1.44617651e-11 10.054000n 1.42063028e-11 10.056000n 1.39552814e-11 10.058000n 1.37088119e-11 10.060000n 1.34666722e-11 10.062000n 1.32287514e-11 10.064000n 1.29950495e-11 10.066000n 1.27654554e-11 10.068000n 1.25399691e-11 10.070000n 1.23184796e-11 10.072000n 1.21008759e-11 10.074000n 1.18870469e-11 10.076000n 1.16771037e-11 10.078000n 1.14708243e-11 10.080000n 1.12682086e-11 10.082000n 1.10691456e-11 10.084000n 1.08735243e-11 10.086000n 1.06814557e-11 10.088000n 1.04928288e-11 10.090000n 1.03074216e-11 10.092000n 1.0125345e-11 10.094000n 9.94648808e-12 10.096000n 9.77073977e-12 10.098000n 9.59821111e-12 10.100000n 9.42856904e-12 10.102000n 9.26203558e-12 10.104000n 9.09838871e-12 10.106000n 8.93773944e-12 10.108000n 8.77986572e-12 10.110000n 8.62476757e-12 10.112000n 8.47233395e-12 10.114000n 8.32267588e-12 10.116000n 8.17568235e-12 10.118000n 8.03124234e-12 10.120000n 7.88935584e-12 10.122000n 7.75002285e-12 10.124000n 7.61313235e-12 10.126000n 7.47857332e-12 10.128000n 7.34645678e-12 10.130000n 7.2166717e-12 10.132000n 7.0892181e-12 10.134000n 6.96398494e-12 10.136000n 6.84097223e-12 10.138000n 6.72006895e-12 10.140000n 6.6013861e-12 10.142000n 6.48481269e-12 10.144000n 6.37023767e-12 10.146000n 6.25766106e-12 10.148000n 6.14719387e-12 10.150000n 6.03861405e-12 10.152000n 5.93192162e-12 10.154000n 5.82711657e-12 10.156000n 5.72419889e-12 10.158000n 5.62305758e-12 10.160000n 5.52369261e-12 10.162000n 5.42610401e-12 10.164000n 5.33029176e-12 10.166000n 5.23614485e-12 10.168000n 5.14366327e-12 10.170000n 5.05273601e-12 10.172000n 4.96347408e-12 10.174000n 4.87576646e-12 10.176000n 4.78972417e-12 10.178000n 4.70501416e-12 10.180000n 4.62196947e-12 10.182000n 4.54025706e-12 10.184000n 4.46009896e-12 10.186000n 4.38127312e-12 10.188000n 4.30389058e-12 10.190000n 4.2278403e-12 10.192000n 4.15323331e-12 10.194000n 4.07984757e-12 10.196000n 4.0077941e-12 10.198000n 3.93696187e-12 10.200000n 3.86735088e-12 10.202000n 3.79907217e-12 10.204000n 3.7320147e-12 10.206000n 3.66606745e-12 10.208000n 3.60123042e-12 10.210000n 3.53761465e-12 10.212000n 3.47522011e-12 10.214000n 3.41382478e-12 10.216000n 3.35342865e-12 10.218000n 3.29425376e-12 10.220000n 3.23607807e-12 10.222000n 3.17890159e-12 10.224000n 3.1227243e-12 10.226000n 3.06754622e-12 10.228000n 3.01336733e-12 10.230000n 2.96018765e-12 10.232000n 2.90789615e-12 10.234000n 2.85649282e-12 10.236000n 2.80597767e-12 10.238000n 2.75646173e-12 10.240000n 2.70772293e-12 10.242000n 2.65987232e-12 10.244000n 2.61290989e-12 10.246000n 2.56672461e-12 10.248000n 2.52142751e-12 10.250000n 2.47690757e-12 10.252000n 2.43316478e-12 10.254000n 2.39019915e-12 10.256000n 2.34789965e-12 10.258000n 2.30648833e-12 10.260000n 2.26574315e-12 10.262000n 2.2256641e-12 10.264000n 2.1863622e-12 10.266000n 2.14772644e-12 10.268000n 2.10975681e-12 10.270000n 2.07256434e-12 10.272000n 2.03592698e-12 10.274000n 1.99995576e-12 10.276000n 1.96465066e-12 10.278000n 1.92990068e-12 10.280000n 1.89581684e-12 10.282000n 1.8622881e-12 10.284000n 1.8294255e-12 10.286000n 1.79711801e-12 10.288000n 1.76536563e-12 10.290000n 1.73416836e-12 10.292000n 1.70352621e-12 10.294000n 1.67343917e-12 10.296000n 1.64390723e-12 10.298000n 1.61481939e-12 10.300000n 1.58628666e-12 10.302000n 1.55830904e-12 10.304000n 1.53077551e-12 10.306000n 1.50368606e-12 10.308000n 1.47715173e-12 10.310000n 1.45106149e-12 10.312000n 1.42541534e-12 10.314000n 1.40021328e-12 10.316000n 1.37556633e-12 10.318000n 1.35125244e-12 10.320000n 1.32738265e-12 10.322000n 1.30395694e-12 10.324000n 1.2808643e-12 10.326000n 1.25821575e-12 10.328000n 1.23601129e-12 10.330000n 1.2141399e-12 10.332000n 1.1927126e-12 10.334000n 1.17161836e-12 10.336000n 1.15096821e-12 10.338000n 1.13065113e-12 10.340000n 1.11066711e-12 10.342000n 1.09101617e-12 10.344000n 1.07180931e-12 10.346000n 1.05282449e-12 10.348000n 1.03428377e-12 10.350000n 1.01596509e-12 10.352000n 9.97979477e-13 10.354000n 9.80437953e-13 10.356000n 9.63118474e-13 10.358000n 9.46021039e-13 10.360000n 9.29367694e-13 10.362000n 9.12936393e-13 10.364000n 8.96838159e-13 10.366000n 8.8096197e-13 10.368000n 8.65418848e-13 10.370000n 8.5009777e-13 10.372000n 8.35109759e-13 10.374000n 8.20343793e-13 10.376000n 8.05799871e-13 10.378000n 7.91589017e-13 10.380000n 7.77600206e-13 10.382000n 7.63833441e-13 10.384000n 7.50399742e-13 10.386000n 7.37188088e-13 10.388000n 7.24087457e-13 10.390000n 7.11319892e-13 10.392000n 6.98774372e-13 10.394000n 6.86450896e-13 10.396000n 6.74238443e-13 10.398000n 6.62359056e-13 10.400000n 6.50701715e-13 10.402000n 6.39155395e-13 10.404000n 6.27942143e-13 10.406000n 6.16839912e-13 10.408000n 6.05848705e-13 10.410000n 5.95190564e-13 10.412000n 5.84643445e-13 10.414000n 5.74318371e-13 10.416000n 5.64215341e-13 10.418000n 5.54223334e-13 10.420000n 5.44453371e-13 10.422000n 5.34794431e-13 10.424000n 5.25357535e-13 10.426000n 5.16142684e-13 10.428000n 5.07038855e-13 10.430000n 4.98046049e-13 10.432000n 4.89275287e-13 10.434000n 4.80615547e-13 10.436000n 4.7206683e-13 10.438000n 4.63740157e-13 10.440000n 4.55524507e-13 10.442000n 4.47530901e-13 10.444000n 4.39648318e-13 10.446000n 4.31876757e-13 10.448000n 4.24216218e-13 10.450000n 4.16777723e-13 10.452000n 4.09339229e-13 10.454000n 4.0212278e-13 10.456000n 3.95017352e-13 10.458000n 3.88022947e-13 10.460000n 3.81250587e-13 10.462000n 3.74478226e-13 10.464000n 3.67816888e-13 10.466000n 3.61377595e-13 10.468000n 3.54938301e-13 10.470000n 3.48721052e-13 10.472000n 3.42503803e-13 10.474000n 3.36508599e-13 10.476000n 3.30513394e-13 10.478000n 3.24740235e-13 10.480000n 3.18967075e-13 10.482000n 3.13304938e-13 10.484000n 3.07753822e-13 10.486000n 3.0231373e-13 10.488000n 2.96984659e-13 10.490000n 2.91766611e-13 10.492000n 2.86659585e-13 10.494000n 2.81552559e-13 10.496000n 2.76556555e-13 10.498000n 2.71671574e-13 10.500000n 2.66897615e-13 10.502000n 2.62123656e-13 10.504000n 2.57571742e-13 10.506000n 2.53019827e-13 10.508000n 2.48578935e-13 10.510000n 2.44138043e-13 10.512000n 2.39808173e-13 10.514000n 2.35589326e-13 10.516000n 2.31481501e-13 10.518000n 2.27373675e-13 10.520000n 2.23376873e-13 10.522000n 2.1938007e-13 10.524000n 2.15494289e-13 10.526000n 2.11719531e-13 10.528000n 2.07944773e-13 10.530000n 2.04281037e-13 10.532000n 2.00617301e-13 10.534000n 1.97175609e-13 10.536000n 1.93622895e-13 10.538000n 1.90181204e-13 10.540000n 1.86850535e-13 10.542000n 1.83519866e-13 10.544000n 1.80300219e-13 10.546000n 1.77080572e-13 10.548000n 1.73971948e-13 10.550000n 1.70974346e-13 10.552000n 1.67865721e-13 10.554000n 1.64979141e-13 10.556000n 1.61981539e-13 10.558000n 1.59205982e-13 10.560000n 1.56319402e-13 10.562000n 1.53543844e-13 10.564000n 1.50879309e-13 10.566000n 1.48214774e-13 10.568000n 1.45550239e-13 10.570000n 1.42996726e-13 10.572000n 1.40554235e-13 10.574000n 1.38000722e-13 10.576000n 1.35558231e-13 10.578000n 1.33226763e-13 10.580000n 1.30784272e-13 10.582000n 1.28563826e-13 10.584000n 1.26232358e-13 10.586000n 1.24011912e-13 10.588000n 1.21791466e-13 10.590000n 1.19682042e-13 10.592000n 1.17572618e-13 10.594000n 1.15463195e-13 10.596000n 1.13464793e-13 10.598000n 1.11466392e-13 10.600000n 1.0946799e-13 10.602000n 1.07580611e-13 10.604000n 1.05693232e-13 10.606000n 1.03805853e-13 10.608000n 1.01918474e-13 10.610000n 1.00142117e-13 10.612000n 9.836576e-14 10.614000n 9.65894031e-14 10.616000n 9.49240686e-14 10.618000n 9.32587341e-14 10.620000n 9.15933995e-14 10.622000n 8.9928065e-14 10.624000n 8.83737528e-14 10.626000n 8.68194405e-14 10.628000n 8.52651283e-14 10.630000n 8.38218384e-14 10.632000n 8.22675261e-14 10.634000n 8.08242362e-14 10.636000n 7.93809463e-14 10.638000n 7.80486786e-14 10.640000n 7.66053887e-14 10.642000n 7.52731211e-14 10.644000n 7.39408534e-14 10.646000n 7.26085858e-14 10.648000n 7.13873405e-14 10.650000n 7.01660952e-14 10.652000n 6.88338275e-14 10.654000n 6.76125822e-14 10.656000n 6.65023592e-14 10.658000n 6.52811138e-14 10.660000n 6.41708908e-14 10.662000n 6.29496455e-14 10.664000n 6.18394225e-14 10.666000n 6.08402217e-14 10.668000n 5.97299987e-14 10.670000n 5.86197757e-14 10.672000n 5.7620575e-14 10.674000n 5.66213743e-14 10.676000n 5.56221735e-14 10.678000n 5.46229728e-14 10.680000n 5.36237721e-14 10.682000n 5.27355937e-14 10.684000n 5.17363929e-14 10.686000n 5.08482145e-14 10.688000n 4.99600361e-14 10.690000n 4.90718577e-14 10.692000n 4.81836793e-14 10.694000n 4.74065232e-14 10.696000n 4.65183447e-14 10.698000n 4.57411886e-14 10.700000n 4.48530102e-14 10.702000n 4.40758541e-14 10.704000n 4.3298698e-14 10.706000n 4.25215418e-14 10.708000n 4.1855408e-14 10.710000n 4.10782519e-14 10.712000n 4.03010958e-14 10.714000n 3.9634962e-14 10.716000n 3.89688282e-14 10.718000n 3.83026943e-14 10.720000n 3.75255382e-14 10.722000n 3.68594044e-14 10.724000n 3.63042929e-14 10.726000n 3.56381591e-14 10.728000n 3.49720253e-14 10.730000n 3.44169138e-14 10.732000n 3.37507799e-14 10.734000n 3.31956684e-14 10.736000n 3.25295346e-14 10.738000n 3.19744231e-14 10.740000n 3.14193116e-14 10.742000n 3.08642001e-14 10.744000n 3.03090886e-14 10.746000n 2.97539771e-14 10.748000n 2.93098879e-14 10.750000n 2.87547763e-14 10.752000n 2.81996648e-14 10.754000n 2.77555756e-14 10.756000n 2.73114864e-14 10.758000n 2.67563749e-14 10.760000n 2.63122857e-14 10.762000n 2.58681965e-14 10.764000n 2.54241073e-14 10.766000n 2.49800181e-14 10.768000n 2.45359288e-14 10.770000n 2.40918396e-14 10.772000n 2.36477504e-14 10.774000n 2.32036612e-14 10.776000n 2.2759572e-14 10.778000n 2.24265051e-14 10.780000n 2.19824159e-14 10.782000n 2.1649349e-14 10.784000n 2.12052598e-14 10.786000n 2.08721929e-14 10.788000n 2.0539126e-14 10.790000n 2.00950367e-14 10.792000n 1.97619698e-14 10.794000n 1.94289029e-14 10.796000n 1.9095836e-14 10.798000n 1.87627691e-14 10.800000n 1.84297022e-14 10.802000n 1.80966353e-14 10.804000n 1.77635684e-14 10.806000n 1.74305015e-14 10.808000n 1.70974346e-14 10.810000n 1.687539e-14 10.812000n 1.65423231e-14 10.814000n 1.62092562e-14 10.816000n 1.59872116e-14 10.818000n 1.56541446e-14 10.820000n 1.54321e-14 10.822000n 1.50990331e-14 10.824000n 1.48769885e-14 10.826000n 1.46549439e-14 10.828000n 1.4321877e-14 10.830000n 1.40998324e-14 10.832000n 1.38777878e-14 10.834000n 1.36557432e-14 10.836000n 1.33226763e-14 10.838000n 1.31006317e-14 10.840000n 1.28785871e-14 10.842000n 1.26565425e-14 10.844000n 1.24344979e-14 10.846000n 1.22124533e-14 10.848000n 1.19904087e-14 10.850000n 1.17683641e-14 10.852000n 1.15463195e-14 10.854000n 1.14352972e-14 10.856000n 1.12132525e-14 10.858000n 1.09912079e-14 10.860000n 1.07691633e-14 10.862000n 1.05471187e-14 10.864000n 1.04360964e-14 10.866000n 1.02140518e-14 10.868000n 1.01030295e-14 10.870000n 9.88098492e-15 10.872000n 9.65894031e-15 10.874000n 9.54791801e-15 10.876000n 9.32587341e-15 10.878000n 9.2148511e-15 10.880000n 8.9928065e-15 10.882000n 8.8817842e-15 10.884000n 8.65973959e-15 10.886000n 8.54871729e-15 10.888000n 8.43769499e-15 10.890000n 8.21565038e-15 10.892000n 8.10462808e-15 10.894000n 7.99360578e-15 10.896000n 7.88258347e-15 10.898000n 7.66053887e-15 10.900000n 7.54951657e-15 10.902000n 7.43849426e-15 10.904000n 7.32747196e-15 10.906000n 7.21644966e-15 10.908000n 6.99440506e-15 10.910000n 6.88338275e-15 10.912000n 6.77236045e-15 10.914000n 6.66133815e-15 10.916000n 6.55031585e-15 10.918000n 6.43929354e-15 10.920000n 6.32827124e-15 10.922000n 6.21724894e-15 10.924000n 6.10622664e-15 10.926000n 5.99520433e-15 10.928000n 5.88418203e-15 10.930000n 5.77315973e-15 10.932000n 5.66213743e-15 10.934000n 5.55111512e-15 10.936000n 5.44009282e-15 10.938000n 5.44009282e-15 10.940000n 5.32907052e-15 10.942000n 5.21804822e-15 10.944000n 5.10702591e-15 10.946000n 4.99600361e-15 10.948000n 4.88498131e-15 10.950000n 4.88498131e-15 10.952000n 4.77395901e-15 10.954000n 4.6629367e-15 10.956000n 4.5519144e-15 10.958000n 4.5519144e-15 10.960000n 4.4408921e-15 10.962000n 4.3298698e-15 10.964000n 4.21884749e-15 10.966000n 4.21884749e-15 10.968000n 4.10782519e-15 10.970000n 3.99680289e-15 10.972000n 3.99680289e-15 10.974000n 3.88578059e-15 10.976000n 3.88578059e-15 10.978000n 3.77475828e-15 10.980000n 3.66373598e-15 10.982000n 3.66373598e-15 10.984000n 3.55271368e-15 10.986000n 3.55271368e-15 10.988000n 3.44169138e-15 10.990000n 3.44169138e-15 10.992000n 3.33066907e-15 10.994000n 3.21964677e-15 10.996000n 3.21964677e-15 10.998000n 3.10862447e-15 11.000000n 3.10862447e-15 11.002000n 2.99760217e-15 11.004000n 2.99760217e-15 11.006000n 2.88657986e-15 11.008000n 2.88657986e-15 11.010000n 2.88657986e-15 11.012000n 2.77555756e-15 11.014000n 2.77555756e-15 11.016000n 2.66453526e-15 11.018000n 2.66453526e-15 11.020000n 2.55351296e-15 11.022000n 2.55351296e-15 11.024000n 2.55351296e-15 11.026000n 2.44249065e-15 11.028000n 2.44249065e-15 11.030000n 2.33146835e-15 11.032000n 2.33146835e-15 11.034000n 2.33146835e-15 11.036000n 2.22044605e-15 11.038000n 2.22044605e-15 11.040000n 2.22044605e-15 11.042000n 2.10942375e-15 11.044000n 2.10942375e-15 11.046000n 2.10942375e-15 11.048000n 1.99840144e-15 11.050000n 1.99840144e-15 11.052000n 1.99840144e-15 11.054000n 1.88737914e-15 11.056000n 1.88737914e-15 11.058000n 1.88737914e-15 11.060000n 1.77635684e-15 11.062000n 1.77635684e-15 11.064000n 1.77635684e-15 11.066000n 1.77635684e-15 11.068000n 1.66533454e-15 11.070000n 1.66533454e-15 11.072000n 1.66533454e-15 11.074000n 1.55431223e-15 11.076000n 1.55431223e-15 11.078000n 1.55431223e-15 11.080000n 1.55431223e-15 11.082000n 1.44328993e-15 11.084000n 1.44328993e-15 11.086000n 1.44328993e-15 11.088000n 1.44328993e-15 11.090000n 1.44328993e-15 11.092000n 1.33226763e-15 11.094000n 1.33226763e-15 11.096000n 1.33226763e-15 11.098000n 1.33226763e-15 11.100000n 1.22124533e-15 11.102000n 1.22124533e-15 11.104000n 1.22124533e-15 11.106000n 1.22124533e-15 11.108000n 1.22124533e-15 11.110000n 1.11022302e-15 11.112000n 1.11022302e-15 11.114000n 1.11022302e-15 11.116000n 1.11022302e-15 11.118000n 1.11022302e-15 11.120000n 1.11022302e-15 11.122000n 9.99200722e-16 11.124000n 9.99200722e-16 11.126000n 9.99200722e-16 11.128000n 9.99200722e-16 11.130000n 9.99200722e-16 11.132000n 9.99200722e-16 11.134000n 8.8817842e-16 11.136000n 8.8817842e-16 11.138000n 8.8817842e-16 11.140000n 8.8817842e-16 11.142000n 8.8817842e-16 11.144000n 8.8817842e-16 11.146000n 8.8817842e-16 11.148000n 7.77156117e-16 11.150000n 7.77156117e-16 11.152000n 7.77156117e-16 11.154000n 7.77156117e-16 11.156000n 7.77156117e-16 11.158000n 7.77156117e-16 11.160000n 7.77156117e-16 11.162000n 7.77156117e-16 11.164000n 6.66133815e-16 11.166000n 6.66133815e-16 11.168000n 6.66133815e-16 11.170000n 6.66133815e-16 11.172000n 6.66133815e-16 11.174000n 6.66133815e-16 11.176000n 6.66133815e-16 11.178000n 6.66133815e-16 11.180000n 6.66133815e-16 11.182000n 6.66133815e-16 11.184000n 5.55111512e-16 11.186000n 5.55111512e-16 11.188000n 5.55111512e-16 11.190000n 5.55111512e-16 11.192000n 5.55111512e-16 11.194000n 5.55111512e-16 11.196000n 5.55111512e-16 11.198000n 5.55111512e-16 11.200000n 5.55111512e-16 11.202000n 5.55111512e-16 11.204000n 5.55111512e-16 11.206000n 4.4408921e-16 11.208000n 4.4408921e-16 11.210000n 4.4408921e-16 11.212000n 4.4408921e-16 11.214000n 4.4408921e-16 11.216000n 4.4408921e-16 11.218000n 4.4408921e-16 11.220000n 4.4408921e-16 11.222000n 4.4408921e-16 11.224000n 4.4408921e-16 11.226000n 4.4408921e-16 11.228000n 4.4408921e-16 11.230000n 4.4408921e-16 11.232000n 4.4408921e-16 11.234000n 3.33066907e-16 11.236000n 3.33066907e-16 11.238000n 3.33066907e-16 11.240000n 3.33066907e-16 11.242000n 3.33066907e-16 11.244000n 3.33066907e-16 11.246000n 3.33066907e-16 11.248000n 3.33066907e-16 11.250000n 3.33066907e-16 11.252000n 3.33066907e-16 11.254000n 3.33066907e-16 11.256000n 3.33066907e-16 11.258000n 3.33066907e-16 11.260000n 3.33066907e-16 11.262000n 3.33066907e-16 11.264000n 3.33066907e-16 11.266000n 3.33066907e-16 11.268000n 3.33066907e-16 11.270000n 3.33066907e-16 11.272000n 2.22044605e-16 11.274000n 2.22044605e-16 11.276000n 2.22044605e-16 11.278000n 2.22044605e-16 11.280000n 2.22044605e-16 11.282000n 2.22044605e-16 11.284000n 2.22044605e-16 11.286000n 2.22044605e-16 11.288000n 2.22044605e-16 11.290000n 2.22044605e-16 11.292000n 2.22044605e-16 11.294000n 2.22044605e-16 11.296000n 2.22044605e-16 11.298000n 2.22044605e-16 11.300000n 2.22044605e-16 11.302000n 2.22044605e-16 11.304000n 2.22044605e-16 11.306000n 2.22044605e-16 11.308000n 2.22044605e-16 11.310000n 2.22044605e-16 11.312000n 2.22044605e-16 11.314000n 2.22044605e-16 11.316000n 2.22044605e-16 11.318000n 2.22044605e-16 11.320000n 2.22044605e-16 11.322000n 2.22044605e-16 11.324000n 2.22044605e-16 11.326000n 2.22044605e-16 11.328000n 2.22044605e-16 11.330000n 1.11022302e-16 11.332000n 1.11022302e-16 11.334000n 1.11022302e-16 11.336000n 1.11022302e-16 11.338000n 1.11022302e-16 11.340000n 1.11022302e-16 11.342000n 1.11022302e-16 11.344000n 1.11022302e-16 11.346000n 1.11022302e-16 11.348000n 1.11022302e-16 11.350000n 1.11022302e-16 11.352000n 1.11022302e-16 11.354000n 1.11022302e-16 11.356000n 1.11022302e-16 11.358000n 1.11022302e-16 11.360000n 1.11022302e-16 11.362000n 1.11022302e-16 11.364000n 1.11022302e-16 11.366000n 1.11022302e-16 11.368000n 1.11022302e-16 11.370000n 1.11022302e-16 11.372000n 1.11022302e-16 11.374000n 1.11022302e-16 11.376000n 1.11022302e-16 11.378000n 1.11022302e-16 11.380000n 1.11022302e-16 11.382000n 1.11022302e-16 11.384000n 1.11022302e-16 11.386000n 1.11022302e-16 11.388000n 1.11022302e-16 11.390000n 1.11022302e-16 11.392000n 1.11022302e-16 11.394000n 1.11022302e-16 11.396000n 1.11022302e-16 11.398000n 1.11022302e-16 11.400000n 1.11022302e-16 11.402000n 1.11022302e-16 11.404000n 1.11022302e-16 11.406000n 1.11022302e-16 11.408000n 1.11022302e-16 11.410000n 1.11022302e-16 11.412000n 1.11022302e-16 11.414000n 1.11022302e-16 11.416000n 1.11022302e-16 11.418000n 1.11022302e-16 11.420000n 1.11022302e-16 11.422000n 1.11022302e-16 11.424000n 1.11022302e-16 11.426000n 1.11022302e-16 11.428000n 1.11022302e-16 11.430000n 1.11022302e-16 11.432000n 1.11022302e-16 11.434000n 1.11022302e-16 11.436000n 1.11022302e-16 11.438000n 1.11022302e-16 11.440000n 1.11022302e-16 11.442000n 1.11022302e-16 11.444000n 1.11022302e-16 11.446000n 1.11022302e-16 11.448000n 1.11022302e-16 11.450000n 1.11022302e-16 11.452000n 0 11.454000n 0 11.456000n 0 11.458000n 0 11.460000n 0 11.462000n 0 11.464000n 0 11.466000n 0 11.468000n 0 11.470000n 0 11.472000n 0 11.474000n 0 11.476000n 0 11.478000n 0 11.480000n 0 11.482000n 0 11.484000n 0 11.486000n 0 11.488000n 0 11.490000n 0 11.492000n 0 11.494000n 0 11.496000n 0 11.498000n 0 11.500000n 0 11.502000n 0 11.504000n 0 11.506000n 0 11.508000n 0 11.510000n 0 11.512000n 0 11.514000n 0 11.516000n 0 11.518000n 0 11.520000n 0 11.522000n 0 11.524000n 0 11.526000n 0 11.528000n 0 11.530000n 0 11.532000n 0 11.534000n 0 11.536000n 0 11.538000n 0 11.540000n 0 11.542000n 0 11.544000n 0 11.546000n 0 11.548000n 0 11.550000n 0 11.552000n 0 11.554000n 0 11.556000n 0 11.558000n 0 11.560000n 0 11.562000n 0 11.564000n 0 11.566000n 0 11.568000n 0 11.570000n 0 11.572000n 0 11.574000n 0 11.576000n 0 11.578000n 0 11.580000n 0 11.582000n 0 11.584000n 0 11.586000n 0 11.588000n 0 11.590000n 0 11.592000n 0 11.594000n 0 11.596000n 0 11.598000n 0 11.600000n 0 11.602000n 0 11.604000n 0 11.606000n 0 11.608000n 0 11.610000n 0 11.612000n 0 11.614000n 0 11.616000n 0 11.618000n 0 11.620000n 0 11.622000n 0 11.624000n 0 11.626000n 0 11.628000n 0 11.630000n 0 11.632000n 0 11.634000n 0 11.636000n 0 11.638000n 0 11.640000n 0 11.642000n 0 11.644000n 0 11.646000n 0 11.648000n 0 11.650000n 0 11.652000n 0 11.654000n 0 11.656000n 0 11.658000n 0 11.660000n 0 11.662000n 0 11.664000n 0 11.666000n 0 11.668000n 0 11.670000n 0 11.672000n 0 11.674000n 0 11.676000n 0 11.678000n 0 11.680000n 0 11.682000n 0 11.684000n 0 11.686000n 0 11.688000n 0 11.690000n 0 11.692000n 0 11.694000n 0 11.696000n 0 11.698000n 0 11.700000n 0 11.702000n 0 11.704000n 0 11.706000n 0 11.708000n 0 11.710000n 0 11.712000n 0 11.714000n 0 11.716000n 0 11.718000n 0 11.720000n 0 11.722000n 0 11.724000n 0 11.726000n 0 11.728000n 0 11.730000n 0 11.732000n 0 11.734000n 0 11.736000n 0 11.738000n 0 11.740000n 0 11.742000n 0 11.744000n 0 11.746000n 0 11.748000n 0 11.750000n 0 11.752000n 0 11.754000n 0 11.756000n 0 11.758000n 0 11.760000n 0 11.762000n 0 11.764000n 0 11.766000n 0 11.768000n 0 11.770000n 0 11.772000n 0 11.774000n 0 11.776000n 0 11.778000n 0 11.780000n 0 11.782000n 0 11.784000n 0 11.786000n 0 11.788000n 0 11.790000n 0 11.792000n 0 11.794000n 0 11.796000n 0 11.798000n 0 11.800000n 0 11.802000n 0 11.804000n 0 11.806000n 0 11.808000n 0 11.810000n 0 11.812000n 0 11.814000n 0 11.816000n 0 11.818000n 0 11.820000n 0 11.822000n 0 11.824000n 0 11.826000n 0 11.828000n 0 11.830000n 0 11.832000n 0 11.834000n 0 11.836000n 0 11.838000n 0 11.840000n 0 11.842000n 0 11.844000n 0 11.846000n 0 11.848000n 0 11.850000n 0 11.852000n 0 11.854000n 0 11.856000n 0 11.858000n 0 11.860000n 0 11.862000n 0 11.864000n 0 11.866000n 0 11.868000n 0 11.870000n 0 11.872000n 0 11.874000n 0 11.876000n 0 11.878000n 0 11.880000n 0 11.882000n 0 11.884000n 0 11.886000n 0 11.888000n 0 11.890000n 0 11.892000n 0 11.894000n 0 11.896000n 0 11.898000n 0 11.900000n 0 11.902000n 0 11.904000n 0 11.906000n 0 11.908000n 0 11.910000n 0 11.912000n 0 11.914000n 0 11.916000n 0 11.918000n 0 11.920000n 0 11.922000n 0 11.924000n 0 11.926000n 0 11.928000n 0 11.930000n 0 11.932000n 0 11.934000n 0 11.936000n 0 11.938000n 0 11.940000n 0 11.942000n 0 11.944000n 0 11.946000n 0 11.948000n 0 11.950000n 0 11.952000n 0 11.954000n 0 11.956000n 0 11.958000n 0 11.960000n 0 11.962000n 0 11.964000n 0 11.966000n 0 11.968000n 0 11.970000n 0 11.972000n 0 11.974000n 0 11.976000n 0 11.978000n 0 11.980000n 0 11.982000n 0 11.984000n 0 11.986000n 0 11.988000n 0 11.990000n 0 11.992000n 0 11.994000n 0 11.996000n 0 11.998000n 0 12.000000n 0 12.002000n 0 12.004000n 0 12.006000n 0 12.008000n 0 12.010000n 0 12.012000n 0 12.014000n 0 12.016000n 0 12.018000n 0 12.020000n 0 12.022000n 0 12.024000n 0 12.026000n 0 12.028000n 0 12.030000n 0 12.032000n 0 12.034000n 0 12.036000n 0 12.038000n 0 12.040000n 0 12.042000n 0 12.044000n 0 12.046000n 0 12.048000n 0 12.050000n 0 12.052000n 0 12.054000n 0 12.056000n 0 12.058000n 0 12.060000n 0 12.062000n 0 12.064000n 0 12.066000n 0 12.068000n 0 12.070000n 0 12.072000n 0 12.074000n 0 12.076000n 0 12.078000n 0 12.080000n 0 12.082000n 0 12.084000n 0 12.086000n 0 12.088000n 0 12.090000n 0 12.092000n 0 12.094000n 0 12.096000n 0 12.098000n 0 12.100000n 0 12.102000n 0 12.104000n 0 12.106000n 0 12.108000n 0 12.110000n 0 12.112000n 0 12.114000n 0 12.116000n 0 12.118000n 0 12.120000n 0 12.122000n 0 12.124000n 0 12.126000n 0 12.128000n 0 12.130000n 0 12.132000n 0 12.134000n 0 12.136000n 0 12.138000n 0 12.140000n 0 12.142000n 0 12.144000n 0 12.146000n 0 12.148000n 0 12.150000n 0 12.152000n 0 12.154000n 0 12.156000n 0 12.158000n 0 12.160000n 0 12.162000n 0 12.164000n 0 12.166000n 0 12.168000n 0 12.170000n 0 12.172000n 0 12.174000n 0 12.176000n 0 12.178000n 0 12.180000n 0 12.182000n 0 12.184000n 0 12.186000n 0 12.188000n 0 12.190000n 0 12.192000n 0 12.194000n 0 12.196000n 0 12.198000n 0 12.200000n 0 12.202000n 0 12.204000n 0 12.206000n 0 12.208000n 0 12.210000n 0 12.212000n 0 12.214000n 0 12.216000n 0 12.218000n 0 12.220000n 0 12.222000n 0 12.224000n 0 12.226000n 0 12.228000n 0 12.230000n 0 12.232000n 0 12.234000n 0 12.236000n 0 12.238000n 0 12.240000n 0 12.242000n 0 12.244000n 0 12.246000n 0 12.248000n 0 12.250000n 0 12.252000n 0 12.254000n 0 12.256000n 0 12.258000n 0 12.260000n 0 12.262000n 0 12.264000n 0 12.266000n 0 12.268000n 0 12.270000n 0 12.272000n 0 12.274000n 0 12.276000n 0 12.278000n 0 12.280000n 0 12.282000n 0 12.284000n 0 12.286000n 0 12.288000n 0 12.290000n 0 12.292000n 0 12.294000n 0 12.296000n 0 12.298000n 0 12.300000n 0 12.302000n 0 12.304000n 0 12.306000n 0 12.308000n 0 12.310000n 0 12.312000n 0 12.314000n 0 12.316000n 0 12.318000n 0 12.320000n 0 12.322000n 0 12.324000n 0 12.326000n 0 12.328000n 0 12.330000n 0 12.332000n 0 12.334000n 0 12.336000n 0 12.338000n 0 12.340000n 0 12.342000n 0 12.344000n 0 12.346000n 0 12.348000n 0 12.350000n 0 12.352000n 0 12.354000n 0 12.356000n 0 12.358000n 0 12.360000n 0 12.362000n 0 12.364000n 0 12.366000n 0 12.368000n 0 12.370000n 0 12.372000n 0 12.374000n 0 12.376000n 0 12.378000n 0 12.380000n 0 12.382000n 0 12.384000n 0 12.386000n 0 12.388000n 0 12.390000n 0 12.392000n 0 12.394000n 0 12.396000n 0 12.398000n 0 12.400000n 0 12.402000n 0 12.404000n 0 12.406000n 0 12.408000n 0 12.410000n 0 12.412000n 0 12.414000n 0 12.416000n 0 12.418000n 0 12.420000n 0 12.422000n 0 12.424000n 0 12.426000n 0 12.428000n 0 12.430000n 0 12.432000n 0 12.434000n 0 12.436000n 0 12.438000n 0 12.440000n 0 12.442000n 0 12.444000n 0 12.446000n 0 12.448000n 0 12.450000n 0 12.452000n 0 12.454000n 0 12.456000n 0 12.458000n 0 12.460000n 0 12.462000n 0 12.464000n 0 12.466000n 0 12.468000n 0 12.470000n 0 12.472000n 0 12.474000n 0 12.476000n 0 12.478000n 0 12.480000n 0 12.482000n 0 12.484000n 0 12.486000n 0 12.488000n 0 12.490000n 0 12.492000n 0 12.494000n 0 12.496000n 0 12.498000n 0 12.500000n 0 12.502000n 0 12.504000n 0 12.506000n 0 12.508000n 0 12.510000n 0 12.512000n 0 12.514000n 0 12.516000n 0 12.518000n 0 12.520000n 0 12.522000n 0 12.524000n 0 12.526000n 0 12.528000n 0 12.530000n 0 12.532000n 0 12.534000n 0 12.536000n 0 12.538000n 0 12.540000n 0 12.542000n 0 12.544000n 0 12.546000n 0 12.548000n 0 12.550000n 0 12.552000n 0 12.554000n 0 12.556000n 0 12.558000n 0 12.560000n 0 12.562000n 0 12.564000n 0 12.566000n 0 12.568000n 0 12.570000n 0 12.572000n 0 12.574000n 0 12.576000n 0 12.578000n 0 12.580000n 0 12.582000n 0 12.584000n 0 12.586000n 0 12.588000n 0 12.590000n 0 12.592000n 0 12.594000n 0 12.596000n 0 12.598000n 0 12.600000n 0 12.602000n 0 12.604000n 0 12.606000n 0 12.608000n 0 12.610000n 0 12.612000n 0 12.614000n 0 12.616000n 0 12.618000n 0 12.620000n 0 12.622000n 0 12.624000n 0 12.626000n 0 12.628000n 0 12.630000n 0 12.632000n 0 12.634000n 0 12.636000n 0 12.638000n 0 12.640000n 0 12.642000n 0 12.644000n 0 12.646000n 0 12.648000n 0 12.650000n 0 12.652000n 0 12.654000n 0 12.656000n 0 12.658000n 0 12.660000n 0 12.662000n 0 12.664000n 0 12.666000n 0 12.668000n 0 12.670000n 0 12.672000n 0 12.674000n 0 12.676000n 0 12.678000n 0 12.680000n 0 12.682000n 0 12.684000n 0 12.686000n 0 12.688000n 0 12.690000n 0 12.692000n 0 12.694000n 0 12.696000n 0 12.698000n 0 12.700000n 0 12.702000n 0 12.704000n 0 12.706000n 0 12.708000n 0 12.710000n 0 12.712000n 0 12.714000n 0 12.716000n 0 12.718000n 0 12.720000n 0 12.722000n 0 12.724000n 0 12.726000n 0 12.728000n 0 12.730000n 0 12.732000n 0 12.734000n 0 12.736000n 0 12.738000n 0 12.740000n 0 12.742000n 0 12.744000n 0 12.746000n 0 12.748000n 0 12.750000n 0 12.752000n 0 12.754000n 0 12.756000n 0 12.758000n 0 12.760000n 0 12.762000n 0 12.764000n 0 12.766000n 0 12.768000n 0 12.770000n 0 12.772000n 0 12.774000n 0 12.776000n 0 12.778000n 0 12.780000n 0 12.782000n 0 12.784000n 0 12.786000n 0 12.788000n 0 12.790000n 0 12.792000n 0 12.794000n 0 12.796000n 0 12.798000n 0 12.800000n 0 12.802000n 0 12.804000n 0 12.806000n 0 12.808000n 0 12.810000n 0 12.812000n 0 12.814000n 0 12.816000n 0 12.818000n 0 12.820000n 0 12.822000n 0 12.824000n 0 12.826000n 0 12.828000n 0 12.830000n 0 12.832000n 0 12.834000n 0 12.836000n 0 12.838000n 0 12.840000n 0 12.842000n 0 12.844000n 0 12.846000n 0 12.848000n 0 12.850000n 0 12.852000n 0 12.854000n 0 12.856000n 0 12.858000n 0 12.860000n 0 12.862000n 0 12.864000n 0 12.866000n 0 12.868000n 0 12.870000n 0 12.872000n 0 12.874000n 0 12.876000n 0 12.878000n 0 12.880000n 0 12.882000n 0 12.884000n 0 12.886000n 0 12.888000n 0 12.890000n 0 12.892000n 0 12.894000n 0 12.896000n 0 12.898000n 0 12.900000n 0 12.902000n 0 12.904000n 0 12.906000n 0 12.908000n 0 12.910000n 0 12.912000n 0 12.914000n 0 12.916000n 0 12.918000n 0 12.920000n 0 12.922000n 0 12.924000n 0 12.926000n 0 12.928000n 0 12.930000n 0 12.932000n 0 12.934000n 0 12.936000n 0 12.938000n 0 12.940000n 0 12.942000n 0 12.944000n 0 12.946000n 0 12.948000n 0 12.950000n 0 12.952000n 0 12.954000n 0 12.956000n 0 12.958000n 0 12.960000n 0 12.962000n 0 12.964000n 0 12.966000n 0 12.968000n 0 12.970000n 0 12.972000n 0 12.974000n 0 12.976000n 0 12.978000n 0 12.980000n 0 12.982000n 0 12.984000n 0 12.986000n 0 12.988000n 0 12.990000n 0 12.992000n 0 12.994000n 0 12.996000n 0 12.998000n 0 13.000000n 0 13.002000n 0 13.004000n 0 13.006000n 0 13.008000n 0 13.010000n 0 13.012000n 0 13.014000n 0 13.016000n 0 13.018000n 0 13.020000n 0 13.022000n 0 13.024000n 0 13.026000n 0 13.028000n 0 13.030000n 0 13.032000n 0 13.034000n 0 13.036000n 0 13.038000n 0 13.040000n 0 13.042000n 0 13.044000n 0 13.046000n 0 13.048000n 0 13.050000n 0 13.052000n 0 13.054000n 0 13.056000n 0 13.058000n 0 13.060000n 0 13.062000n 0 13.064000n 0 13.066000n 0 13.068000n 0 13.070000n 0 13.072000n 0 13.074000n 0 13.076000n 0 13.078000n 0 13.080000n 0 13.082000n 0 13.084000n 0 13.086000n 0 13.088000n 0 13.090000n 0 13.092000n 0 13.094000n 0 13.096000n 0 13.098000n 0 13.100000n 0 13.102000n 0 13.104000n 0 13.106000n 0 13.108000n 0 13.110000n 0 13.112000n 0 13.114000n 0 13.116000n 0 13.118000n 0 13.120000n 0 13.122000n 0 13.124000n 0 13.126000n 0 13.128000n 0 13.130000n 0 13.132000n 0 13.134000n 0 13.136000n 0 13.138000n 0 13.140000n 0 13.142000n 0 13.144000n 0 13.146000n 0 13.148000n 0 13.150000n 0 13.152000n 0 13.154000n 0 13.156000n 0 13.158000n 0 13.160000n 0 13.162000n 0 13.164000n 0 13.166000n 0 13.168000n 0 13.170000n 0 13.172000n 0 13.174000n 0 13.176000n 0 13.178000n 0 13.180000n 0 13.182000n 0 13.184000n 0 13.186000n 0 13.188000n 0 13.190000n 0 13.192000n 0 13.194000n 0 13.196000n 0 13.198000n 0 13.200000n 0 13.202000n 0 13.204000n 0 13.206000n 0 13.208000n 0 13.210000n 0 13.212000n 0 13.214000n 0 13.216000n 0 13.218000n 0 13.220000n 0 13.222000n 0 13.224000n 0 13.226000n 0 13.228000n 0 13.230000n 0 13.232000n 0 13.234000n 0 13.236000n 0 13.238000n 0 13.240000n 0 13.242000n 0 13.244000n 0 13.246000n 0 13.248000n 0 13.250000n 0 13.252000n 0 13.254000n 0 13.256000n 0 13.258000n 0 13.260000n 0 13.262000n 0 13.264000n 0 13.266000n 0 13.268000n 0 13.270000n 0 13.272000n 0 13.274000n 0 13.276000n 0 13.278000n 0 13.280000n 0 13.282000n 0 13.284000n 0 13.286000n 0 13.288000n 0 13.290000n 0 13.292000n 0 13.294000n 0 13.296000n 0 13.298000n 0 13.300000n 0 13.302000n 0 13.304000n 0 13.306000n 0 13.308000n 0 13.310000n 0 13.312000n 0 13.314000n 0 13.316000n 0 13.318000n 0 13.320000n 0 13.322000n 0 13.324000n 0 13.326000n 0 13.328000n 0 13.330000n 0 13.332000n 0 13.334000n 0 13.336000n 0 13.338000n 0 13.340000n 0 13.342000n 0 13.344000n 0 13.346000n 0 13.348000n 0 13.350000n 0 13.352000n 0 13.354000n 0 13.356000n 0 13.358000n 0 13.360000n 0 13.362000n 0 13.364000n 0 13.366000n 0 13.368000n 0 13.370000n 0 13.372000n 0 13.374000n 0 13.376000n 0 13.378000n 0 13.380000n 0 13.382000n 0 13.384000n 0 13.386000n 0 13.388000n 0 13.390000n 0 13.392000n 0 13.394000n 0 13.396000n 0 13.398000n 0 13.400000n 0 13.402000n 0 13.404000n 0 13.406000n 0 13.408000n 0 13.410000n 0 13.412000n 0 13.414000n 0 13.416000n 0 13.418000n 0 13.420000n 0 13.422000n 0 13.424000n 0 13.426000n 0 13.428000n 0 13.430000n 0 13.432000n 0 13.434000n 0 13.436000n 0 13.438000n 0 13.440000n 0 13.442000n 0 13.444000n 0 13.446000n 0 13.448000n 0 13.450000n 0 13.452000n 0 13.454000n 0 13.456000n 0 13.458000n 0 13.460000n 0 13.462000n 0 13.464000n 0 13.466000n 0 13.468000n 0 13.470000n 0 13.472000n 0 13.474000n 0 13.476000n 0 13.478000n 0 13.480000n 0 13.482000n 0 13.484000n 0 13.486000n 0 13.488000n 0 13.490000n 0 13.492000n 0 13.494000n 0 13.496000n 0 13.498000n 0 13.500000n 0 13.502000n 0 13.504000n 0 13.506000n 0 13.508000n 0 13.510000n 0 13.512000n 0 13.514000n 0 13.516000n 0 13.518000n 0 13.520000n 0 13.522000n 0 13.524000n 0 13.526000n 0 13.528000n 0 13.530000n 0 13.532000n 0 13.534000n 0 13.536000n 0 13.538000n 0 13.540000n 0 13.542000n 0 13.544000n 0 13.546000n 0 13.548000n 0 13.550000n 0 13.552000n 0 13.554000n 0 13.556000n 0 13.558000n 0 13.560000n 0 13.562000n 0 13.564000n 0 13.566000n 0 13.568000n 0 13.570000n 0 13.572000n 0 13.574000n 0 13.576000n 0 13.578000n 0 13.580000n 0 13.582000n 0 13.584000n 0 13.586000n 0 13.588000n 0 13.590000n 0 13.592000n 0 13.594000n 0 13.596000n 0 13.598000n 0 13.600000n 0 13.602000n 0 13.604000n 0 13.606000n 0 13.608000n 0 13.610000n 0 13.612000n 0 13.614000n 0 13.616000n 0 13.618000n 0 13.620000n 0 13.622000n 0 13.624000n 0 13.626000n 0 13.628000n 0 13.630000n 0 13.632000n 0 13.634000n 0 13.636000n 0 13.638000n 0 13.640000n 0 13.642000n 0 13.644000n 0 13.646000n 0 13.648000n 0 13.650000n 0 13.652000n 0 13.654000n 0 13.656000n 0 13.658000n 0 13.660000n 0 13.662000n 0 13.664000n 0 13.666000n 0 13.668000n 0 13.670000n 0 13.672000n 0 13.674000n 0 13.676000n 0 13.678000n 0 13.680000n 0 13.682000n 0 13.684000n 0 13.686000n 0 13.688000n 0 13.690000n 0 13.692000n 0 13.694000n 0 13.696000n 0 13.698000n 0 13.700000n 0 13.702000n 0 13.704000n 0 13.706000n 0 13.708000n 0 13.710000n 0 13.712000n 0 13.714000n 0 13.716000n 0 13.718000n 0 13.720000n 0 13.722000n 0 13.724000n 0 13.726000n 0 13.728000n 0 13.730000n 0 13.732000n 0 13.734000n 0 13.736000n 0 13.738000n 0 13.740000n 0 13.742000n 0 13.744000n 0 13.746000n 0 13.748000n 0 13.750000n 0 13.752000n 0 13.754000n 0 13.756000n 0 13.758000n 0 13.760000n 0 13.762000n 0 13.764000n 0 13.766000n 0 13.768000n 0 13.770000n 0 13.772000n 0 13.774000n 0 13.776000n 0 13.778000n 0 13.780000n 0 13.782000n 0 13.784000n 0 13.786000n 0 13.788000n 0 13.790000n 0 13.792000n 0 13.794000n 0 13.796000n 0 13.798000n 0 13.800000n 0 13.802000n 0 13.804000n 0 13.806000n 0 13.808000n 0 13.810000n 0 13.812000n 0 13.814000n 0 13.816000n 0 13.818000n 0 13.820000n 0 13.822000n 0 13.824000n 0 13.826000n 0 13.828000n 0 13.830000n 0 13.832000n 0 13.834000n 0 13.836000n 0 13.838000n 0 13.840000n 0 13.842000n 0 13.844000n 0 13.846000n 0 13.848000n 0 13.850000n 0 13.852000n 0 13.854000n 0 13.856000n 0 13.858000n 0 13.860000n 0 13.862000n 0 13.864000n 0 13.866000n 0 13.868000n 0 13.870000n 0 13.872000n 0 13.874000n 0 13.876000n 0 13.878000n 0 13.880000n 0 13.882000n 0 13.884000n 0 13.886000n 0 13.888000n 0 13.890000n 0 13.892000n 0 13.894000n 0 13.896000n 0 13.898000n 0 13.900000n 0 13.902000n 0 13.904000n 0 13.906000n 0 13.908000n 0 13.910000n 0 13.912000n 0 13.914000n 0 13.916000n 0 13.918000n 0 13.920000n 0 13.922000n 0 13.924000n 0 13.926000n 0 13.928000n 0 13.930000n 0 13.932000n 0 13.934000n 0 13.936000n 0 13.938000n 0 13.940000n 0 13.942000n 0 13.944000n 0 13.946000n 0 13.948000n 0 13.950000n 0 13.952000n 0 13.954000n 0 13.956000n 0 13.958000n 0 13.960000n 0 13.962000n 0 13.964000n 0 13.966000n 0 13.968000n 0 13.970000n 0 13.972000n 0 13.974000n 0 13.976000n 0 13.978000n 0 13.980000n 0 13.982000n 0 13.984000n 0 13.986000n 0 13.988000n 0 13.990000n 0 13.992000n 0 13.994000n 0 13.996000n 0 13.998000n 0 14.000000n 0)
VGDNB GDNB 0 PWL(0.000000n 1 0.002000n 1 0.004000n 1 0.006000n 1 0.008000n 1 0.010000n 1 0.012000n 1 0.014000n 1 0.016000n 1 0.018000n 1 0.020000n 1 0.022000n 1 0.024000n 1 0.026000n 1 0.028000n 1 0.030000n 1 0.032000n 1 0.034000n 1 0.036000n 1 0.038000n 1 0.040000n 1 0.042000n 1 0.044000n 1 0.046000n 1 0.048000n 1 0.050000n 1 0.052000n 1 0.054000n 1 0.056000n 1 0.058000n 1 0.060000n 1 0.062000n 1 0.064000n 1 0.066000n 1 0.068000n 1 0.070000n 1 0.072000n 1 0.074000n 1 0.076000n 1 0.078000n 1 0.080000n 1 0.082000n 1 0.084000n 1 0.086000n 1 0.088000n 1 0.090000n 1 0.092000n 1 0.094000n 1 0.096000n 1 0.098000n 1 0.100000n 1 0.102000n 1 0.104000n 1 0.106000n 1 0.108000n 1 0.110000n 1 0.112000n 1 0.114000n 1 0.116000n 1 0.118000n 1 0.120000n 1 0.122000n 1 0.124000n 1 0.126000n 1 0.128000n 1 0.130000n 1 0.132000n 1 0.134000n 1 0.136000n 1 0.138000n 1 0.140000n 1 0.142000n 1 0.144000n 1 0.146000n 1 0.148000n 1 0.150000n 1 0.152000n 1 0.154000n 1 0.156000n 1 0.158000n 1 0.160000n 1 0.162000n 1 0.164000n 1 0.166000n 1 0.168000n 1 0.170000n 1 0.172000n 1 0.174000n 1 0.176000n 1 0.178000n 1 0.180000n 1 0.182000n 1 0.184000n 1 0.186000n 1 0.188000n 1 0.190000n 1 0.192000n 1 0.194000n 1 0.196000n 1 0.198000n 1 0.200000n 1 0.202000n 1 0.204000n 1 0.206000n 1 0.208000n 1 0.210000n 1 0.212000n 1 0.214000n 1 0.216000n 1 0.218000n 1 0.220000n 1 0.222000n 1 0.224000n 1 0.226000n 1 0.228000n 1 0.230000n 1 0.232000n 1 0.234000n 1 0.236000n 1 0.238000n 1 0.240000n 1 0.242000n 1 0.244000n 1 0.246000n 1 0.248000n 1 0.250000n 1 0.252000n 1 0.254000n 1 0.256000n 1 0.258000n 1 0.260000n 1 0.262000n 1 0.264000n 1 0.266000n 1 0.268000n 1 0.270000n 1 0.272000n 1 0.274000n 1 0.276000n 1 0.278000n 1 0.280000n 1 0.282000n 1 0.284000n 1 0.286000n 1 0.288000n 1 0.290000n 1 0.292000n 1 0.294000n 1 0.296000n 1 0.298000n 1 0.300000n 1 0.302000n 1 0.304000n 1 0.306000n 1 0.308000n 1 0.310000n 1 0.312000n 1 0.314000n 1 0.316000n 1 0.318000n 1 0.320000n 1 0.322000n 1 0.324000n 1 0.326000n 1 0.328000n 1 0.330000n 1 0.332000n 1 0.334000n 1 0.336000n 1 0.338000n 1 0.340000n 1 0.342000n 1 0.344000n 1 0.346000n 1 0.348000n 1 0.350000n 1 0.352000n 1 0.354000n 1 0.356000n 1 0.358000n 1 0.360000n 1 0.362000n 1 0.364000n 1 0.366000n 1 0.368000n 1 0.370000n 1 0.372000n 1 0.374000n 1 0.376000n 1 0.378000n 1 0.380000n 1 0.382000n 1 0.384000n 1 0.386000n 1 0.388000n 1 0.390000n 1 0.392000n 1 0.394000n 1 0.396000n 1 0.398000n 1 0.400000n 1 0.402000n 1 0.404000n 1 0.406000n 1 0.408000n 1 0.410000n 1 0.412000n 1 0.414000n 1 0.416000n 1 0.418000n 1 0.420000n 1 0.422000n 1 0.424000n 1 0.426000n 1 0.428000n 1 0.430000n 1 0.432000n 1 0.434000n 1 0.436000n 1 0.438000n 1 0.440000n 1 0.442000n 1 0.444000n 1 0.446000n 1 0.448000n 1 0.450000n 1 0.452000n 1 0.454000n 1 0.456000n 1 0.458000n 1 0.460000n 1 0.462000n 1 0.464000n 1 0.466000n 1 0.468000n 1 0.470000n 1 0.472000n 1 0.474000n 1 0.476000n 1 0.478000n 1 0.480000n 1 0.482000n 1 0.484000n 1 0.486000n 1 0.488000n 1 0.490000n 1 0.492000n 1 0.494000n 1 0.496000n 1 0.498000n 1 0.500000n 1 0.502000n 1 0.504000n 1 0.506000n 1 0.508000n 1 0.510000n 1 0.512000n 1 0.514000n 1 0.516000n 1 0.518000n 1 0.520000n 1 0.522000n 1 0.524000n 1 0.526000n 1 0.528000n 1 0.530000n 1 0.532000n 1 0.534000n 1 0.536000n 1 0.538000n 1 0.540000n 1 0.542000n 1 0.544000n 1 0.546000n 1 0.548000n 1 0.550000n 1 0.552000n 1 0.554000n 1 0.556000n 1 0.558000n 1 0.560000n 1 0.562000n 1 0.564000n 1 0.566000n 1 0.568000n 1 0.570000n 1 0.572000n 1 0.574000n 1 0.576000n 1 0.578000n 1 0.580000n 1 0.582000n 1 0.584000n 1 0.586000n 1 0.588000n 1 0.590000n 1 0.592000n 1 0.594000n 1 0.596000n 1 0.598000n 1 0.600000n 1 0.602000n 1 0.604000n 1 0.606000n 1 0.608000n 1 0.610000n 1 0.612000n 1 0.614000n 1 0.616000n 1 0.618000n 1 0.620000n 1 0.622000n 1 0.624000n 1 0.626000n 1 0.628000n 1 0.630000n 1 0.632000n 1 0.634000n 1 0.636000n 1 0.638000n 1 0.640000n 1 0.642000n 1 0.644000n 1 0.646000n 1 0.648000n 1 0.650000n 1 0.652000n 1 0.654000n 1 0.656000n 1 0.658000n 1 0.660000n 1 0.662000n 1 0.664000n 1 0.666000n 1 0.668000n 1 0.670000n 1 0.672000n 1 0.674000n 1 0.676000n 1 0.678000n 1 0.680000n 1 0.682000n 1 0.684000n 1 0.686000n 1 0.688000n 1 0.690000n 1 0.692000n 1 0.694000n 1 0.696000n 1 0.698000n 1 0.700000n 1 0.702000n 1 0.704000n 1 0.706000n 1 0.708000n 1 0.710000n 1 0.712000n 1 0.714000n 1 0.716000n 1 0.718000n 1 0.720000n 1 0.722000n 1 0.724000n 1 0.726000n 1 0.728000n 1 0.730000n 1 0.732000n 1 0.734000n 1 0.736000n 1 0.738000n 1 0.740000n 1 0.742000n 1 0.744000n 1 0.746000n 1 0.748000n 1 0.750000n 1 0.752000n 1 0.754000n 1 0.756000n 1 0.758000n 1 0.760000n 1 0.762000n 1 0.764000n 1 0.766000n 1 0.768000n 1 0.770000n 1 0.772000n 1 0.774000n 1 0.776000n 1 0.778000n 1 0.780000n 1 0.782000n 1 0.784000n 1 0.786000n 1 0.788000n 1 0.790000n 1 0.792000n 1 0.794000n 1 0.796000n 1 0.798000n 1 0.800000n 1 0.802000n 1 0.804000n 1 0.806000n 1 0.808000n 1 0.810000n 1 0.812000n 1 0.814000n 1 0.816000n 1 0.818000n 1 0.820000n 1 0.822000n 1 0.824000n 1 0.826000n 1 0.828000n 1 0.830000n 1 0.832000n 1 0.834000n 1 0.836000n 1 0.838000n 1 0.840000n 1 0.842000n 1 0.844000n 1 0.846000n 1 0.848000n 1 0.850000n 1 0.852000n 1 0.854000n 1 0.856000n 1 0.858000n 1 0.860000n 1 0.862000n 1 0.864000n 1 0.866000n 1 0.868000n 1 0.870000n 1 0.872000n 1 0.874000n 1 0.876000n 1 0.878000n 1 0.880000n 1 0.882000n 1 0.884000n 1 0.886000n 1 0.888000n 1 0.890000n 1 0.892000n 1 0.894000n 1 0.896000n 1 0.898000n 1 0.900000n 1 0.902000n 1 0.904000n 1 0.906000n 1 0.908000n 1 0.910000n 1 0.912000n 1 0.914000n 1 0.916000n 1 0.918000n 1 0.920000n 1 0.922000n 1 0.924000n 1 0.926000n 1 0.928000n 1 0.930000n 1 0.932000n 1 0.934000n 1 0.936000n 1 0.938000n 1 0.940000n 1 0.942000n 1 0.944000n 1 0.946000n 1 0.948000n 1 0.950000n 1 0.952000n 1 0.954000n 1 0.956000n 1 0.958000n 1 0.960000n 1 0.962000n 1 0.964000n 1 0.966000n 1 0.968000n 1 0.970000n 1 0.972000n 1 0.974000n 1 0.976000n 1 0.978000n 1 0.980000n 1 0.982000n 1 0.984000n 1 0.986000n 1 0.988000n 1 0.990000n 1 0.992000n 1 0.994000n 1 0.996000n 1 0.998000n 1 1.000000n 1 1.002000n 1 1.004000n 1 1.006000n 1 1.008000n 1 1.010000n 1 1.012000n 1 1.014000n 1 1.016000n 1 1.018000n 1 1.020000n 1 1.022000n 1 1.024000n 1 1.026000n 1 1.028000n 1 1.030000n 1 1.032000n 1 1.034000n 1 1.036000n 1 1.038000n 1 1.040000n 1 1.042000n 1 1.044000n 1 1.046000n 1 1.048000n 1 1.050000n 1 1.052000n 1 1.054000n 1 1.056000n 1 1.058000n 1 1.060000n 1 1.062000n 1 1.064000n 1 1.066000n 1 1.068000n 1 1.070000n 1 1.072000n 1 1.074000n 1 1.076000n 1 1.078000n 1 1.080000n 1 1.082000n 1 1.084000n 1 1.086000n 1 1.088000n 1 1.090000n 1 1.092000n 1 1.094000n 1 1.096000n 1 1.098000n 1 1.100000n 1 1.102000n 1 1.104000n 1 1.106000n 1 1.108000n 1 1.110000n 1 1.112000n 1 1.114000n 1 1.116000n 1 1.118000n 1 1.120000n 1 1.122000n 1 1.124000n 1 1.126000n 1 1.128000n 1 1.130000n 1 1.132000n 1 1.134000n 1 1.136000n 1 1.138000n 1 1.140000n 1 1.142000n 1 1.144000n 1 1.146000n 1 1.148000n 1 1.150000n 1 1.152000n 1 1.154000n 1 1.156000n 1 1.158000n 1 1.160000n 1 1.162000n 1 1.164000n 1 1.166000n 1 1.168000n 1 1.170000n 1 1.172000n 1 1.174000n 1 1.176000n 1 1.178000n 1 1.180000n 1 1.182000n 1 1.184000n 1 1.186000n 1 1.188000n 1 1.190000n 1 1.192000n 1 1.194000n 1 1.196000n 1 1.198000n 1 1.200000n 1 1.202000n 1 1.204000n 1 1.206000n 1 1.208000n 1 1.210000n 1 1.212000n 1 1.214000n 1 1.216000n 1 1.218000n 1 1.220000n 1 1.222000n 1 1.224000n 1 1.226000n 1 1.228000n 1 1.230000n 1 1.232000n 1 1.234000n 1 1.236000n 1 1.238000n 1 1.240000n 1 1.242000n 1 1.244000n 1 1.246000n 1 1.248000n 1 1.250000n 1 1.252000n 1 1.254000n 1 1.256000n 1 1.258000n 1 1.260000n 1 1.262000n 1 1.264000n 1 1.266000n 1 1.268000n 1 1.270000n 1 1.272000n 1 1.274000n 1 1.276000n 1 1.278000n 1 1.280000n 1 1.282000n 1 1.284000n 1 1.286000n 1 1.288000n 1 1.290000n 1 1.292000n 1 1.294000n 1 1.296000n 1 1.298000n 1 1.300000n 1 1.302000n 1 1.304000n 1 1.306000n 1 1.308000n 1 1.310000n 1 1.312000n 1 1.314000n 1 1.316000n 1 1.318000n 1 1.320000n 1 1.322000n 1 1.324000n 1 1.326000n 1 1.328000n 1 1.330000n 1 1.332000n 1 1.334000n 1 1.336000n 1 1.338000n 1 1.340000n 1 1.342000n 1 1.344000n 1 1.346000n 1 1.348000n 1 1.350000n 1 1.352000n 1 1.354000n 1 1.356000n 1 1.358000n 1 1.360000n 1 1.362000n 1 1.364000n 1 1.366000n 1 1.368000n 1 1.370000n 1 1.372000n 1 1.374000n 1 1.376000n 1 1.378000n 1 1.380000n 1 1.382000n 1 1.384000n 1 1.386000n 1 1.388000n 1 1.390000n 1 1.392000n 1 1.394000n 1 1.396000n 1 1.398000n 1 1.400000n 1 1.402000n 1 1.404000n 1 1.406000n 1 1.408000n 1 1.410000n 1 1.412000n 1 1.414000n 1 1.416000n 1 1.418000n 1 1.420000n 1 1.422000n 1 1.424000n 1 1.426000n 1 1.428000n 1 1.430000n 1 1.432000n 1 1.434000n 1 1.436000n 1 1.438000n 1 1.440000n 1 1.442000n 1 1.444000n 1 1.446000n 1 1.448000n 1 1.450000n 1 1.452000n 1 1.454000n 1 1.456000n 1 1.458000n 1 1.460000n 1 1.462000n 1 1.464000n 1 1.466000n 1 1.468000n 1 1.470000n 1 1.472000n 1 1.474000n 1 1.476000n 1 1.478000n 1 1.480000n 1 1.482000n 1 1.484000n 1 1.486000n 1 1.488000n 1 1.490000n 1 1.492000n 1 1.494000n 1 1.496000n 1 1.498000n 1 1.500000n 1 1.502000n 1 1.504000n 1 1.506000n 1 1.508000n 1 1.510000n 1 1.512000n 1 1.514000n 1 1.516000n 1 1.518000n 1 1.520000n 1 1.522000n 1 1.524000n 1 1.526000n 1 1.528000n 1 1.530000n 1 1.532000n 1 1.534000n 1 1.536000n 1 1.538000n 1 1.540000n 1 1.542000n 1 1.544000n 1 1.546000n 1 1.548000n 1 1.550000n 1 1.552000n 1 1.554000n 1 1.556000n 1 1.558000n 1 1.560000n 1 1.562000n 1 1.564000n 1 1.566000n 1 1.568000n 1 1.570000n 1 1.572000n 1 1.574000n 1 1.576000n 1 1.578000n 1 1.580000n 1 1.582000n 1 1.584000n 1 1.586000n 1 1.588000n 1 1.590000n 1 1.592000n 1 1.594000n 1 1.596000n 1 1.598000n 1 1.600000n 1 1.602000n 1 1.604000n 1 1.606000n 1 1.608000n 1 1.610000n 1 1.612000n 1 1.614000n 1 1.616000n 1 1.618000n 1 1.620000n 1 1.622000n 1 1.624000n 1 1.626000n 1 1.628000n 1 1.630000n 1 1.632000n 1 1.634000n 1 1.636000n 1 1.638000n 1 1.640000n 1 1.642000n 1 1.644000n 1 1.646000n 1 1.648000n 1 1.650000n 1 1.652000n 1 1.654000n 1 1.656000n 1 1.658000n 1 1.660000n 1 1.662000n 1 1.664000n 1 1.666000n 1 1.668000n 1 1.670000n 1 1.672000n 1 1.674000n 1 1.676000n 1 1.678000n 1 1.680000n 1 1.682000n 1 1.684000n 1 1.686000n 1 1.688000n 1 1.690000n 1 1.692000n 1 1.694000n 1 1.696000n 1 1.698000n 1 1.700000n 1 1.702000n 1 1.704000n 1 1.706000n 1 1.708000n 1 1.710000n 1 1.712000n 1 1.714000n 1 1.716000n 1 1.718000n 1 1.720000n 1 1.722000n 1 1.724000n 1 1.726000n 1 1.728000n 1 1.730000n 1 1.732000n 1 1.734000n 1 1.736000n 1 1.738000n 1 1.740000n 1 1.742000n 1 1.744000n 1 1.746000n 1 1.748000n 1 1.750000n 1 1.752000n 1 1.754000n 1 1.756000n 1 1.758000n 1 1.760000n 1 1.762000n 1 1.764000n 1 1.766000n 1 1.768000n 1 1.770000n 1 1.772000n 1 1.774000n 1 1.776000n 1 1.778000n 1 1.780000n 1 1.782000n 1 1.784000n 1 1.786000n 1 1.788000n 1 1.790000n 1 1.792000n 1 1.794000n 1 1.796000n 1 1.798000n 1 1.800000n 1 1.802000n 1 1.804000n 1 1.806000n 1 1.808000n 1 1.810000n 1 1.812000n 1 1.814000n 1 1.816000n 1 1.818000n 1 1.820000n 1 1.822000n 1 1.824000n 1 1.826000n 1 1.828000n 1 1.830000n 1 1.832000n 1 1.834000n 1 1.836000n 1 1.838000n 1 1.840000n 1 1.842000n 1 1.844000n 1 1.846000n 1 1.848000n 1 1.850000n 1 1.852000n 1 1.854000n 1 1.856000n 1 1.858000n 1 1.860000n 1 1.862000n 1 1.864000n 1 1.866000n 1 1.868000n 1 1.870000n 1 1.872000n 1 1.874000n 1 1.876000n 1 1.878000n 1 1.880000n 1 1.882000n 1 1.884000n 1 1.886000n 1 1.888000n 1 1.890000n 1 1.892000n 1 1.894000n 1 1.896000n 1 1.898000n 1 1.900000n 1 1.902000n 1 1.904000n 1 1.906000n 1 1.908000n 1 1.910000n 1 1.912000n 1 1.914000n 1 1.916000n 1 1.918000n 1 1.920000n 1 1.922000n 1 1.924000n 1 1.926000n 1 1.928000n 1 1.930000n 1 1.932000n 1 1.934000n 1 1.936000n 1 1.938000n 1 1.940000n 1 1.942000n 1 1.944000n 1 1.946000n 1 1.948000n 1 1.950000n 1 1.952000n 1 1.954000n 1 1.956000n 1 1.958000n 1 1.960000n 1 1.962000n 1 1.964000n 1 1.966000n 1 1.968000n 1 1.970000n 1 1.972000n 1 1.974000n 1 1.976000n 1 1.978000n 1 1.980000n 1 1.982000n 1 1.984000n 1 1.986000n 1 1.988000n 1 1.990000n 1 1.992000n 1 1.994000n 1 1.996000n 1 1.998000n 1 2.000000n 1 2.002000n 1 2.004000n 1 2.006000n 1 2.008000n 1 2.010000n 1 2.012000n 1 2.014000n 1 2.016000n 1 2.018000n 1 2.020000n 1 2.022000n 1 2.024000n 1 2.026000n 1 2.028000n 1 2.030000n 1 2.032000n 1 2.034000n 1 2.036000n 1 2.038000n 1 2.040000n 1 2.042000n 1 2.044000n 1 2.046000n 1 2.048000n 1 2.050000n 1 2.052000n 1 2.054000n 1 2.056000n 1 2.058000n 1 2.060000n 1 2.062000n 1 2.064000n 1 2.066000n 1 2.068000n 1 2.070000n 1 2.072000n 1 2.074000n 1 2.076000n 1 2.078000n 1 2.080000n 1 2.082000n 1 2.084000n 1 2.086000n 1 2.088000n 1 2.090000n 1 2.092000n 1 2.094000n 1 2.096000n 1 2.098000n 1 2.100000n 1 2.102000n 1 2.104000n 1 2.106000n 1 2.108000n 1 2.110000n 1 2.112000n 1 2.114000n 1 2.116000n 1 2.118000n 1 2.120000n 1 2.122000n 1 2.124000n 1 2.126000n 1 2.128000n 1 2.130000n 1 2.132000n 1 2.134000n 1 2.136000n 1 2.138000n 1 2.140000n 1 2.142000n 1 2.144000n 1 2.146000n 1 2.148000n 1 2.150000n 1 2.152000n 1 2.154000n 1 2.156000n 1 2.158000n 1 2.160000n 1 2.162000n 1 2.164000n 1 2.166000n 1 2.168000n 1 2.170000n 1 2.172000n 1 2.174000n 1 2.176000n 1 2.178000n 1 2.180000n 1 2.182000n 1 2.184000n 1 2.186000n 1 2.188000n 1 2.190000n 1 2.192000n 1 2.194000n 1 2.196000n 1 2.198000n 1 2.200000n 1 2.202000n 1 2.204000n 1 2.206000n 1 2.208000n 1 2.210000n 1 2.212000n 1 2.214000n 1 2.216000n 1 2.218000n 1 2.220000n 1 2.222000n 1 2.224000n 1 2.226000n 1 2.228000n 1 2.230000n 1 2.232000n 1 2.234000n 1 2.236000n 1 2.238000n 1 2.240000n 1 2.242000n 1 2.244000n 1 2.246000n 1 2.248000n 1 2.250000n 1 2.252000n 1 2.254000n 1 2.256000n 1 2.258000n 1 2.260000n 1 2.262000n 1 2.264000n 1 2.266000n 1 2.268000n 1 2.270000n 1 2.272000n 1 2.274000n 1 2.276000n 1 2.278000n 1 2.280000n 1 2.282000n 1 2.284000n 1 2.286000n 1 2.288000n 1 2.290000n 1 2.292000n 1 2.294000n 1 2.296000n 1 2.298000n 1 2.300000n 1 2.302000n 1 2.304000n 1 2.306000n 1 2.308000n 1 2.310000n 1 2.312000n 1 2.314000n 1 2.316000n 1 2.318000n 1 2.320000n 1 2.322000n 1 2.324000n 1 2.326000n 1 2.328000n 1 2.330000n 1 2.332000n 1 2.334000n 1 2.336000n 1 2.338000n 1 2.340000n 1 2.342000n 1 2.344000n 1 2.346000n 1 2.348000n 1 2.350000n 1 2.352000n 1 2.354000n 1 2.356000n 1 2.358000n 1 2.360000n 1 2.362000n 1 2.364000n 1 2.366000n 1 2.368000n 1 2.370000n 1 2.372000n 1 2.374000n 1 2.376000n 1 2.378000n 1 2.380000n 1 2.382000n 1 2.384000n 1 2.386000n 1 2.388000n 1 2.390000n 1 2.392000n 1 2.394000n 1 2.396000n 1 2.398000n 1 2.400000n 1 2.402000n 1 2.404000n 1 2.406000n 1 2.408000n 1 2.410000n 1 2.412000n 1 2.414000n 1 2.416000n 1 2.418000n 1 2.420000n 1 2.422000n 1 2.424000n 1 2.426000n 1 2.428000n 1 2.430000n 1 2.432000n 1 2.434000n 1 2.436000n 1 2.438000n 1 2.440000n 1 2.442000n 1 2.444000n 1 2.446000n 1 2.448000n 1 2.450000n 1 2.452000n 1 2.454000n 1 2.456000n 1 2.458000n 1 2.460000n 1 2.462000n 1 2.464000n 1 2.466000n 1 2.468000n 1 2.470000n 1 2.472000n 1 2.474000n 1 2.476000n 1 2.478000n 1 2.480000n 1 2.482000n 1 2.484000n 1 2.486000n 1 2.488000n 1 2.490000n 1 2.492000n 1 2.494000n 1 2.496000n 1 2.498000n 1 2.500000n 1 2.502000n 1 2.504000n 1 2.506000n 1 2.508000n 1 2.510000n 1 2.512000n 1 2.514000n 1 2.516000n 1 2.518000n 1 2.520000n 1 2.522000n 1 2.524000n 1 2.526000n 1 2.528000n 1 2.530000n 1 2.532000n 1 2.534000n 1 2.536000n 1 2.538000n 1 2.540000n 1 2.542000n 1 2.544000n 1 2.546000n 1 2.548000n 1 2.550000n 1 2.552000n 1 2.554000n 1 2.556000n 1 2.558000n 1 2.560000n 1 2.562000n 1 2.564000n 1 2.566000n 1 2.568000n 1 2.570000n 1 2.572000n 1 2.574000n 1 2.576000n 1 2.578000n 1 2.580000n 1 2.582000n 1 2.584000n 1 2.586000n 1 2.588000n 1 2.590000n 1 2.592000n 1 2.594000n 1 2.596000n 1 2.598000n 1 2.600000n 1 2.602000n 1 2.604000n 1 2.606000n 1 2.608000n 1 2.610000n 1 2.612000n 1 2.614000n 1 2.616000n 1 2.618000n 1 2.620000n 1 2.622000n 1 2.624000n 1 2.626000n 1 2.628000n 1 2.630000n 1 2.632000n 1 2.634000n 1 2.636000n 1 2.638000n 1 2.640000n 1 2.642000n 1 2.644000n 1 2.646000n 1 2.648000n 1 2.650000n 1 2.652000n 1 2.654000n 1 2.656000n 1 2.658000n 1 2.660000n 1 2.662000n 1 2.664000n 1 2.666000n 1 2.668000n 1 2.670000n 1 2.672000n 1 2.674000n 1 2.676000n 1 2.678000n 1 2.680000n 1 2.682000n 1 2.684000n 1 2.686000n 1 2.688000n 1 2.690000n 1 2.692000n 1 2.694000n 1 2.696000n 1 2.698000n 1 2.700000n 1 2.702000n 1 2.704000n 1 2.706000n 1 2.708000n 1 2.710000n 1 2.712000n 1 2.714000n 1 2.716000n 1 2.718000n 1 2.720000n 1 2.722000n 1 2.724000n 1 2.726000n 1 2.728000n 1 2.730000n 1 2.732000n 1 2.734000n 1 2.736000n 1 2.738000n 1 2.740000n 1 2.742000n 1 2.744000n 1 2.746000n 1 2.748000n 1 2.750000n 1 2.752000n 1 2.754000n 1 2.756000n 1 2.758000n 1 2.760000n 1 2.762000n 1 2.764000n 1 2.766000n 1 2.768000n 1 2.770000n 1 2.772000n 1 2.774000n 1 2.776000n 1 2.778000n 1 2.780000n 1 2.782000n 1 2.784000n 1 2.786000n 1 2.788000n 1 2.790000n 1 2.792000n 1 2.794000n 1 2.796000n 1 2.798000n 1 2.800000n 1 2.802000n 1 2.804000n 1 2.806000n 1 2.808000n 1 2.810000n 1 2.812000n 1 2.814000n 1 2.816000n 1 2.818000n 1 2.820000n 1 2.822000n 1 2.824000n 1 2.826000n 1 2.828000n 1 2.830000n 1 2.832000n 1 2.834000n 1 2.836000n 1 2.838000n 1 2.840000n 1 2.842000n 1 2.844000n 1 2.846000n 1 2.848000n 1 2.850000n 1 2.852000n 1 2.854000n 1 2.856000n 1 2.858000n 1 2.860000n 1 2.862000n 1 2.864000n 1 2.866000n 1 2.868000n 1 2.870000n 1 2.872000n 1 2.874000n 1 2.876000n 1 2.878000n 1 2.880000n 1 2.882000n 1 2.884000n 1 2.886000n 1 2.888000n 1 2.890000n 1 2.892000n 1 2.894000n 1 2.896000n 1 2.898000n 1 2.900000n 1 2.902000n 1 2.904000n 1 2.906000n 1 2.908000n 1 2.910000n 1 2.912000n 1 2.914000n 1 2.916000n 1 2.918000n 1 2.920000n 1 2.922000n 1 2.924000n 1 2.926000n 1 2.928000n 1 2.930000n 1 2.932000n 1 2.934000n 1 2.936000n 1 2.938000n 1 2.940000n 1 2.942000n 1 2.944000n 1 2.946000n 1 2.948000n 1 2.950000n 1 2.952000n 1 2.954000n 1 2.956000n 1 2.958000n 1 2.960000n 1 2.962000n 1 2.964000n 1 2.966000n 1 2.968000n 1 2.970000n 1 2.972000n 1 2.974000n 1 2.976000n 1 2.978000n 1 2.980000n 1 2.982000n 1 2.984000n 1 2.986000n 1 2.988000n 1 2.990000n 1 2.992000n 1 2.994000n 1 2.996000n 1 2.998000n 1 3.000000n 1 3.002000n 1 3.004000n 1 3.006000n 1 3.008000n 1 3.010000n 1 3.012000n 1 3.014000n 1 3.016000n 1 3.018000n 1 3.020000n 1 3.022000n 1 3.024000n 1 3.026000n 1 3.028000n 1 3.030000n 1 3.032000n 1 3.034000n 1 3.036000n 1 3.038000n 1 3.040000n 1 3.042000n 1 3.044000n 1 3.046000n 1 3.048000n 1 3.050000n 1 3.052000n 1 3.054000n 1 3.056000n 1 3.058000n 1 3.060000n 1 3.062000n 1 3.064000n 1 3.066000n 1 3.068000n 1 3.070000n 1 3.072000n 1 3.074000n 1 3.076000n 1 3.078000n 1 3.080000n 1 3.082000n 1 3.084000n 1 3.086000n 1 3.088000n 1 3.090000n 1 3.092000n 1 3.094000n 1 3.096000n 1 3.098000n 1 3.100000n 1 3.102000n 1 3.104000n 1 3.106000n 1 3.108000n 1 3.110000n 1 3.112000n 1 3.114000n 1 3.116000n 1 3.118000n 1 3.120000n 1 3.122000n 1 3.124000n 1 3.126000n 1 3.128000n 1 3.130000n 1 3.132000n 1 3.134000n 1 3.136000n 1 3.138000n 1 3.140000n 1 3.142000n 1 3.144000n 1 3.146000n 1 3.148000n 1 3.150000n 1 3.152000n 1 3.154000n 1 3.156000n 1 3.158000n 1 3.160000n 1 3.162000n 1 3.164000n 1 3.166000n 1 3.168000n 1 3.170000n 1 3.172000n 1 3.174000n 1 3.176000n 1 3.178000n 1 3.180000n 1 3.182000n 1 3.184000n 1 3.186000n 1 3.188000n 1 3.190000n 1 3.192000n 1 3.194000n 1 3.196000n 1 3.198000n 1 3.200000n 1 3.202000n 1 3.204000n 1 3.206000n 1 3.208000n 1 3.210000n 1 3.212000n 1 3.214000n 1 3.216000n 1 3.218000n 1 3.220000n 1 3.222000n 1 3.224000n 1 3.226000n 1 3.228000n 1 3.230000n 1 3.232000n 1 3.234000n 1 3.236000n 1 3.238000n 1 3.240000n 1 3.242000n 1 3.244000n 1 3.246000n 1 3.248000n 1 3.250000n 1 3.252000n 1 3.254000n 1 3.256000n 1 3.258000n 1 3.260000n 1 3.262000n 1 3.264000n 1 3.266000n 1 3.268000n 1 3.270000n 1 3.272000n 1 3.274000n 1 3.276000n 1 3.278000n 1 3.280000n 1 3.282000n 1 3.284000n 1 3.286000n 1 3.288000n 1 3.290000n 1 3.292000n 1 3.294000n 1 3.296000n 1 3.298000n 1 3.300000n 1 3.302000n 1 3.304000n 1 3.306000n 1 3.308000n 1 3.310000n 1 3.312000n 1 3.314000n 1 3.316000n 1 3.318000n 1 3.320000n 1 3.322000n 1 3.324000n 1 3.326000n 1 3.328000n 1 3.330000n 1 3.332000n 1 3.334000n 1 3.336000n 1 3.338000n 1 3.340000n 1 3.342000n 1 3.344000n 1 3.346000n 1 3.348000n 1 3.350000n 1 3.352000n 1 3.354000n 1 3.356000n 1 3.358000n 1 3.360000n 1 3.362000n 1 3.364000n 1 3.366000n 1 3.368000n 1 3.370000n 1 3.372000n 1 3.374000n 1 3.376000n 1 3.378000n 1 3.380000n 1 3.382000n 1 3.384000n 1 3.386000n 1 3.388000n 1 3.390000n 1 3.392000n 1 3.394000n 1 3.396000n 1 3.398000n 1 3.400000n 1 3.402000n 1 3.404000n 1 3.406000n 1 3.408000n 1 3.410000n 1 3.412000n 1 3.414000n 1 3.416000n 1 3.418000n 1 3.420000n 1 3.422000n 1 3.424000n 1 3.426000n 1 3.428000n 1 3.430000n 1 3.432000n 1 3.434000n 1 3.436000n 1 3.438000n 1 3.440000n 1 3.442000n 1 3.444000n 1 3.446000n 1 3.448000n 1 3.450000n 1 3.452000n 1 3.454000n 1 3.456000n 1 3.458000n 1 3.460000n 1 3.462000n 1 3.464000n 1 3.466000n 1 3.468000n 1 3.470000n 1 3.472000n 1 3.474000n 1 3.476000n 1 3.478000n 1 3.480000n 1 3.482000n 1 3.484000n 1 3.486000n 1 3.488000n 1 3.490000n 1 3.492000n 1 3.494000n 1 3.496000n 1 3.498000n 1 3.500000n 1 3.502000n 1 3.504000n 1 3.506000n 1 3.508000n 1 3.510000n 1 3.512000n 1 3.514000n 1 3.516000n 1 3.518000n 1 3.520000n 1 3.522000n 1 3.524000n 1 3.526000n 1 3.528000n 1 3.530000n 1 3.532000n 1 3.534000n 1 3.536000n 1 3.538000n 1 3.540000n 1 3.542000n 1 3.544000n 1 3.546000n 1 3.548000n 1 3.550000n 1 3.552000n 1 3.554000n 1 3.556000n 1 3.558000n 1 3.560000n 1 3.562000n 1 3.564000n 1 3.566000n 1 3.568000n 1 3.570000n 1 3.572000n 1 3.574000n 1 3.576000n 1 3.578000n 1 3.580000n 1 3.582000n 1 3.584000n 1 3.586000n 1 3.588000n 1 3.590000n 1 3.592000n 1 3.594000n 1 3.596000n 1 3.598000n 1 3.600000n 1 3.602000n 1 3.604000n 1 3.606000n 1 3.608000n 1 3.610000n 1 3.612000n 1 3.614000n 1 3.616000n 1 3.618000n 1 3.620000n 1 3.622000n 1 3.624000n 1 3.626000n 1 3.628000n 1 3.630000n 1 3.632000n 1 3.634000n 1 3.636000n 1 3.638000n 1 3.640000n 1 3.642000n 1 3.644000n 1 3.646000n 1 3.648000n 1 3.650000n 1 3.652000n 1 3.654000n 1 3.656000n 1 3.658000n 1 3.660000n 1 3.662000n 1 3.664000n 1 3.666000n 1 3.668000n 1 3.670000n 1 3.672000n 1 3.674000n 1 3.676000n 1 3.678000n 1 3.680000n 1 3.682000n 1 3.684000n 1 3.686000n 1 3.688000n 1 3.690000n 1 3.692000n 1 3.694000n 1 3.696000n 1 3.698000n 1 3.700000n 1 3.702000n 1 3.704000n 1 3.706000n 1 3.708000n 1 3.710000n 1 3.712000n 1 3.714000n 1 3.716000n 1 3.718000n 1 3.720000n 1 3.722000n 1 3.724000n 1 3.726000n 1 3.728000n 1 3.730000n 1 3.732000n 1 3.734000n 1 3.736000n 1 3.738000n 1 3.740000n 1 3.742000n 1 3.744000n 1 3.746000n 1 3.748000n 1 3.750000n 1 3.752000n 1 3.754000n 1 3.756000n 1 3.758000n 1 3.760000n 1 3.762000n 1 3.764000n 1 3.766000n 1 3.768000n 1 3.770000n 1 3.772000n 1 3.774000n 1 3.776000n 1 3.778000n 1 3.780000n 1 3.782000n 1 3.784000n 1 3.786000n 1 3.788000n 1 3.790000n 1 3.792000n 1 3.794000n 1 3.796000n 1 3.798000n 1 3.800000n 1 3.802000n 1 3.804000n 1 3.806000n 1 3.808000n 1 3.810000n 1 3.812000n 1 3.814000n 1 3.816000n 1 3.818000n 1 3.820000n 1 3.822000n 1 3.824000n 1 3.826000n 1 3.828000n 1 3.830000n 1 3.832000n 1 3.834000n 1 3.836000n 1 3.838000n 1 3.840000n 1 3.842000n 1 3.844000n 1 3.846000n 1 3.848000n 1 3.850000n 1 3.852000n 1 3.854000n 1 3.856000n 1 3.858000n 1 3.860000n 1 3.862000n 1 3.864000n 1 3.866000n 1 3.868000n 1 3.870000n 1 3.872000n 1 3.874000n 1 3.876000n 1 3.878000n 1 3.880000n 1 3.882000n 1 3.884000n 1 3.886000n 1 3.888000n 1 3.890000n 1 3.892000n 1 3.894000n 1 3.896000n 1 3.898000n 1 3.900000n 1 3.902000n 1 3.904000n 1 3.906000n 1 3.908000n 1 3.910000n 1 3.912000n 1 3.914000n 1 3.916000n 1 3.918000n 1 3.920000n 1 3.922000n 1 3.924000n 1 3.926000n 1 3.928000n 1 3.930000n 1 3.932000n 1 3.934000n 1 3.936000n 1 3.938000n 1 3.940000n 1 3.942000n 1 3.944000n 1 3.946000n 1 3.948000n 1 3.950000n 1 3.952000n 1 3.954000n 1 3.956000n 1 3.958000n 1 3.960000n 1 3.962000n 1 3.964000n 1 3.966000n 1 3.968000n 1 3.970000n 1 3.972000n 1 3.974000n 1 3.976000n 1 3.978000n 1 3.980000n 1 3.982000n 1 3.984000n 1 3.986000n 1 3.988000n 1 3.990000n 1 3.992000n 1 3.994000n 1 3.996000n 1 3.998000n 1 4.000000n 1 4.002000n 1 4.004000n 1 4.006000n 1 4.008000n 1 4.010000n 1 4.012000n 1 4.014000n 1 4.016000n 1 4.018000n 1 4.020000n 1 4.022000n 1 4.024000n 1 4.026000n 1 4.028000n 1 4.030000n 1 4.032000n 1 4.034000n 1 4.036000n 1 4.038000n 1 4.040000n 1 4.042000n 1 4.044000n 1 4.046000n 1 4.048000n 1 4.050000n 1 4.052000n 1 4.054000n 1 4.056000n 1 4.058000n 1 4.060000n 1 4.062000n 1 4.064000n 1 4.066000n 1 4.068000n 1 4.070000n 1 4.072000n 1 4.074000n 1 4.076000n 1 4.078000n 1 4.080000n 1 4.082000n 1 4.084000n 1 4.086000n 1 4.088000n 1 4.090000n 1 4.092000n 1 4.094000n 1 4.096000n 1 4.098000n 1 4.100000n 1 4.102000n 1 4.104000n 1 4.106000n 1 4.108000n 1 4.110000n 1 4.112000n 1 4.114000n 1 4.116000n 1 4.118000n 1 4.120000n 1 4.122000n 1 4.124000n 1 4.126000n 1 4.128000n 1 4.130000n 1 4.132000n 1 4.134000n 1 4.136000n 1 4.138000n 1 4.140000n 1 4.142000n 1 4.144000n 1 4.146000n 1 4.148000n 1 4.150000n 1 4.152000n 1 4.154000n 1 4.156000n 1 4.158000n 1 4.160000n 1 4.162000n 1 4.164000n 1 4.166000n 1 4.168000n 1 4.170000n 1 4.172000n 1 4.174000n 1 4.176000n 1 4.178000n 1 4.180000n 1 4.182000n 1 4.184000n 1 4.186000n 1 4.188000n 1 4.190000n 1 4.192000n 1 4.194000n 1 4.196000n 1 4.198000n 1 4.200000n 1 4.202000n 1 4.204000n 1 4.206000n 1 4.208000n 1 4.210000n 1 4.212000n 1 4.214000n 1 4.216000n 1 4.218000n 1 4.220000n 1 4.222000n 1 4.224000n 1 4.226000n 1 4.228000n 1 4.230000n 1 4.232000n 1 4.234000n 1 4.236000n 1 4.238000n 1 4.240000n 1 4.242000n 1 4.244000n 1 4.246000n 1 4.248000n 1 4.250000n 1 4.252000n 1 4.254000n 1 4.256000n 1 4.258000n 1 4.260000n 1 4.262000n 1 4.264000n 1 4.266000n 1 4.268000n 1 4.270000n 1 4.272000n 1 4.274000n 1 4.276000n 1 4.278000n 1 4.280000n 1 4.282000n 1 4.284000n 1 4.286000n 1 4.288000n 1 4.290000n 1 4.292000n 1 4.294000n 1 4.296000n 1 4.298000n 1 4.300000n 1 4.302000n 1 4.304000n 1 4.306000n 1 4.308000n 1 4.310000n 1 4.312000n 1 4.314000n 1 4.316000n 1 4.318000n 1 4.320000n 1 4.322000n 1 4.324000n 1 4.326000n 1 4.328000n 1 4.330000n 1 4.332000n 1 4.334000n 1 4.336000n 1 4.338000n 1 4.340000n 1 4.342000n 1 4.344000n 1 4.346000n 1 4.348000n 1 4.350000n 1 4.352000n 1 4.354000n 1 4.356000n 1 4.358000n 1 4.360000n 1 4.362000n 1 4.364000n 1 4.366000n 1 4.368000n 1 4.370000n 1 4.372000n 1 4.374000n 1 4.376000n 1 4.378000n 1 4.380000n 1 4.382000n 1 4.384000n 1 4.386000n 1 4.388000n 1 4.390000n 1 4.392000n 1 4.394000n 1 4.396000n 1 4.398000n 1 4.400000n 1 4.402000n 1 4.404000n 1 4.406000n 1 4.408000n 1 4.410000n 1 4.412000n 1 4.414000n 1 4.416000n 1 4.418000n 1 4.420000n 1 4.422000n 1 4.424000n 1 4.426000n 1 4.428000n 1 4.430000n 1 4.432000n 1 4.434000n 1 4.436000n 1 4.438000n 1 4.440000n 1 4.442000n 1 4.444000n 1 4.446000n 1 4.448000n 1 4.450000n 1 4.452000n 1 4.454000n 1 4.456000n 1 4.458000n 1 4.460000n 1 4.462000n 1 4.464000n 1 4.466000n 1 4.468000n 1 4.470000n 1 4.472000n 1 4.474000n 1 4.476000n 1 4.478000n 1 4.480000n 1 4.482000n 1 4.484000n 1 4.486000n 1 4.488000n 1 4.490000n 1 4.492000n 1 4.494000n 1 4.496000n 1 4.498000n 1 4.500000n 1 4.502000n 1 4.504000n 1 4.506000n 1 4.508000n 1 4.510000n 1 4.512000n 1 4.514000n 1 4.516000n 1 4.518000n 1 4.520000n 1 4.522000n 1 4.524000n 1 4.526000n 1 4.528000n 1 4.530000n 1 4.532000n 1 4.534000n 1 4.536000n 1 4.538000n 1 4.540000n 1 4.542000n 1 4.544000n 1 4.546000n 1 4.548000n 1 4.550000n 1 4.552000n 1 4.554000n 1 4.556000n 1 4.558000n 1 4.560000n 1 4.562000n 1 4.564000n 1 4.566000n 1 4.568000n 1 4.570000n 1 4.572000n 1 4.574000n 1 4.576000n 1 4.578000n 1 4.580000n 1 4.582000n 1 4.584000n 1 4.586000n 1 4.588000n 1 4.590000n 1 4.592000n 1 4.594000n 1 4.596000n 1 4.598000n 1 4.600000n 1 4.602000n 1 4.604000n 1 4.606000n 1 4.608000n 1 4.610000n 1 4.612000n 1 4.614000n 1 4.616000n 1 4.618000n 1 4.620000n 1 4.622000n 1 4.624000n 1 4.626000n 1 4.628000n 1 4.630000n 1 4.632000n 1 4.634000n 1 4.636000n 1 4.638000n 1 4.640000n 1 4.642000n 1 4.644000n 1 4.646000n 1 4.648000n 1 4.650000n 1 4.652000n 1 4.654000n 1 4.656000n 1 4.658000n 1 4.660000n 1 4.662000n 1 4.664000n 1 4.666000n 1 4.668000n 1 4.670000n 1 4.672000n 1 4.674000n 1 4.676000n 1 4.678000n 1 4.680000n 1 4.682000n 1 4.684000n 1 4.686000n 1 4.688000n 1 4.690000n 1 4.692000n 1 4.694000n 1 4.696000n 1 4.698000n 1 4.700000n 1 4.702000n 1 4.704000n 1 4.706000n 1 4.708000n 1 4.710000n 1 4.712000n 1 4.714000n 1 4.716000n 1 4.718000n 1 4.720000n 1 4.722000n 1 4.724000n 1 4.726000n 1 4.728000n 1 4.730000n 1 4.732000n 1 4.734000n 1 4.736000n 1 4.738000n 1 4.740000n 1 4.742000n 1 4.744000n 1 4.746000n 1 4.748000n 1 4.750000n 1 4.752000n 1 4.754000n 1 4.756000n 1 4.758000n 1 4.760000n 1 4.762000n 1 4.764000n 1 4.766000n 1 4.768000n 1 4.770000n 1 4.772000n 1 4.774000n 1 4.776000n 1 4.778000n 1 4.780000n 1 4.782000n 1 4.784000n 1 4.786000n 1 4.788000n 1 4.790000n 1 4.792000n 1 4.794000n 1 4.796000n 1 4.798000n 1 4.800000n 1 4.802000n 1 4.804000n 1 4.806000n 1 4.808000n 1 4.810000n 1 4.812000n 1 4.814000n 1 4.816000n 1 4.818000n 1 4.820000n 1 4.822000n 1 4.824000n 1 4.826000n 1 4.828000n 1 4.830000n 1 4.832000n 1 4.834000n 1 4.836000n 1 4.838000n 1 4.840000n 1 4.842000n 1 4.844000n 1 4.846000n 1 4.848000n 1 4.850000n 1 4.852000n 1 4.854000n 1 4.856000n 1 4.858000n 1 4.860000n 1 4.862000n 1 4.864000n 1 4.866000n 1 4.868000n 1 4.870000n 1 4.872000n 1 4.874000n 1 4.876000n 1 4.878000n 1 4.880000n 1 4.882000n 1 4.884000n 1 4.886000n 1 4.888000n 1 4.890000n 1 4.892000n 1 4.894000n 1 4.896000n 1 4.898000n 1 4.900000n 1 4.902000n 1 4.904000n 1 4.906000n 1 4.908000n 1 4.910000n 1 4.912000n 1 4.914000n 1 4.916000n 1 4.918000n 1 4.920000n 1 4.922000n 1 4.924000n 1 4.926000n 1 4.928000n 1 4.930000n 1 4.932000n 1 4.934000n 1 4.936000n 1 4.938000n 1 4.940000n 1 4.942000n 1 4.944000n 1 4.946000n 1 4.948000n 1 4.950000n 1 4.952000n 1 4.954000n 1 4.956000n 1 4.958000n 1 4.960000n 1 4.962000n 1 4.964000n 1 4.966000n 1 4.968000n 1 4.970000n 1 4.972000n 1 4.974000n 1 4.976000n 1 4.978000n 1 4.980000n 1 4.982000n 1 4.984000n 1 4.986000n 1 4.988000n 1 4.990000n 1 4.992000n 1 4.994000n 1 4.996000n 1 4.998000n 1 5.000000n 1 5.002000n 1 5.004000n 1 5.006000n 1 5.008000n 1 5.010000n 1 5.012000n 1 5.014000n 1 5.016000n 1 5.018000n 1 5.020000n 1 5.022000n 1 5.024000n 1 5.026000n 1 5.028000n 1 5.030000n 1 5.032000n 1 5.034000n 1 5.036000n 1 5.038000n 1 5.040000n 1 5.042000n 1 5.044000n 1 5.046000n 1 5.048000n 1 5.050000n 1 5.052000n 1 5.054000n 1 5.056000n 1 5.058000n 1 5.060000n 1 5.062000n 1 5.064000n 1 5.066000n 1 5.068000n 1 5.070000n 1 5.072000n 1 5.074000n 1 5.076000n 1 5.078000n 1 5.080000n 1 5.082000n 1 5.084000n 1 5.086000n 1 5.088000n 1 5.090000n 1 5.092000n 1 5.094000n 1 5.096000n 1 5.098000n 1 5.100000n 1 5.102000n 1 5.104000n 1 5.106000n 1 5.108000n 1 5.110000n 1 5.112000n 1 5.114000n 1 5.116000n 1 5.118000n 1 5.120000n 1 5.122000n 1 5.124000n 1 5.126000n 1 5.128000n 1 5.130000n 1 5.132000n 1 5.134000n 1 5.136000n 1 5.138000n 1 5.140000n 1 5.142000n 1 5.144000n 1 5.146000n 1 5.148000n 1 5.150000n 1 5.152000n 1 5.154000n 1 5.156000n 1 5.158000n 1 5.160000n 1 5.162000n 1 5.164000n 1 5.166000n 1 5.168000n 1 5.170000n 1 5.172000n 1 5.174000n 1 5.176000n 1 5.178000n 1 5.180000n 1 5.182000n 1 5.184000n 1 5.186000n 1 5.188000n 1 5.190000n 1 5.192000n 1 5.194000n 1 5.196000n 1 5.198000n 1 5.200000n 1 5.202000n 1 5.204000n 1 5.206000n 1 5.208000n 1 5.210000n 1 5.212000n 1 5.214000n 1 5.216000n 1 5.218000n 1 5.220000n 1 5.222000n 1 5.224000n 1 5.226000n 1 5.228000n 1 5.230000n 1 5.232000n 1 5.234000n 1 5.236000n 1 5.238000n 1 5.240000n 1 5.242000n 1 5.244000n 1 5.246000n 1 5.248000n 1 5.250000n 1 5.252000n 1 5.254000n 1 5.256000n 1 5.258000n 1 5.260000n 1 5.262000n 1 5.264000n 1 5.266000n 1 5.268000n 1 5.270000n 1 5.272000n 1 5.274000n 1 5.276000n 1 5.278000n 1 5.280000n 1 5.282000n 1 5.284000n 1 5.286000n 1 5.288000n 1 5.290000n 1 5.292000n 1 5.294000n 1 5.296000n 1 5.298000n 1 5.300000n 1 5.302000n 1 5.304000n 1 5.306000n 1 5.308000n 1 5.310000n 1 5.312000n 1 5.314000n 1 5.316000n 1 5.318000n 1 5.320000n 1 5.322000n 1 5.324000n 1 5.326000n 1 5.328000n 1 5.330000n 1 5.332000n 1 5.334000n 1 5.336000n 1 5.338000n 1 5.340000n 1 5.342000n 1 5.344000n 1 5.346000n 1 5.348000n 1 5.350000n 1 5.352000n 1 5.354000n 1 5.356000n 1 5.358000n 1 5.360000n 1 5.362000n 1 5.364000n 1 5.366000n 1 5.368000n 1 5.370000n 1 5.372000n 1 5.374000n 1 5.376000n 1 5.378000n 1 5.380000n 1 5.382000n 1 5.384000n 1 5.386000n 1 5.388000n 1 5.390000n 1 5.392000n 1 5.394000n 1 5.396000n 1 5.398000n 1 5.400000n 1 5.402000n 1 5.404000n 1 5.406000n 1 5.408000n 1 5.410000n 1 5.412000n 1 5.414000n 1 5.416000n 1 5.418000n 1 5.420000n 1 5.422000n 1 5.424000n 1 5.426000n 1 5.428000n 1 5.430000n 1 5.432000n 1 5.434000n 1 5.436000n 1 5.438000n 1 5.440000n 1 5.442000n 1 5.444000n 1 5.446000n 1 5.448000n 1 5.450000n 1 5.452000n 1 5.454000n 1 5.456000n 1 5.458000n 1 5.460000n 1 5.462000n 1 5.464000n 1 5.466000n 1 5.468000n 1 5.470000n 1 5.472000n 1 5.474000n 1 5.476000n 1 5.478000n 1 5.480000n 1 5.482000n 1 5.484000n 1 5.486000n 1 5.488000n 1 5.490000n 1 5.492000n 1 5.494000n 1 5.496000n 1 5.498000n 1 5.500000n 1 5.502000n 1 5.504000n 1 5.506000n 1 5.508000n 1 5.510000n 1 5.512000n 1 5.514000n 1 5.516000n 1 5.518000n 1 5.520000n 1 5.522000n 1 5.524000n 1 5.526000n 1 5.528000n 1 5.530000n 1 5.532000n 1 5.534000n 1 5.536000n 1 5.538000n 1 5.540000n 1 5.542000n 1 5.544000n 1 5.546000n 1 5.548000n 1 5.550000n 1 5.552000n 1 5.554000n 1 5.556000n 1 5.558000n 1 5.560000n 1 5.562000n 1 5.564000n 1 5.566000n 1 5.568000n 1 5.570000n 1 5.572000n 1 5.574000n 1 5.576000n 1 5.578000n 1 5.580000n 1 5.582000n 1 5.584000n 1 5.586000n 1 5.588000n 1 5.590000n 1 5.592000n 1 5.594000n 1 5.596000n 1 5.598000n 1 5.600000n 1 5.602000n 1 5.604000n 1 5.606000n 1 5.608000n 1 5.610000n 1 5.612000n 1 5.614000n 1 5.616000n 1 5.618000n 1 5.620000n 1 5.622000n 1 5.624000n 1 5.626000n 1 5.628000n 1 5.630000n 1 5.632000n 1 5.634000n 1 5.636000n 1 5.638000n 1 5.640000n 1 5.642000n 1 5.644000n 1 5.646000n 1 5.648000n 1 5.650000n 1 5.652000n 1 5.654000n 1 5.656000n 1 5.658000n 1 5.660000n 1 5.662000n 1 5.664000n 1 5.666000n 1 5.668000n 1 5.670000n 1 5.672000n 1 5.674000n 1 5.676000n 1 5.678000n 1 5.680000n 1 5.682000n 1 5.684000n 1 5.686000n 1 5.688000n 1 5.690000n 1 5.692000n 1 5.694000n 1 5.696000n 1 5.698000n 1 5.700000n 1 5.702000n 1 5.704000n 1 5.706000n 1 5.708000n 1 5.710000n 1 5.712000n 1 5.714000n 1 5.716000n 1 5.718000n 1 5.720000n 1 5.722000n 1 5.724000n 1 5.726000n 1 5.728000n 1 5.730000n 1 5.732000n 1 5.734000n 1 5.736000n 1 5.738000n 1 5.740000n 1 5.742000n 1 5.744000n 1 5.746000n 1 5.748000n 1 5.750000n 1 5.752000n 1 5.754000n 1 5.756000n 1 5.758000n 1 5.760000n 1 5.762000n 1 5.764000n 1 5.766000n 1 5.768000n 1 5.770000n 1 5.772000n 1 5.774000n 1 5.776000n 1 5.778000n 1 5.780000n 1 5.782000n 1 5.784000n 1 5.786000n 1 5.788000n 1 5.790000n 1 5.792000n 1 5.794000n 1 5.796000n 1 5.798000n 1 5.800000n 1 5.802000n 1 5.804000n 1 5.806000n 1 5.808000n 1 5.810000n 1 5.812000n 1 5.814000n 1 5.816000n 1 5.818000n 1 5.820000n 1 5.822000n 1 5.824000n 1 5.826000n 1 5.828000n 1 5.830000n 1 5.832000n 1 5.834000n 1 5.836000n 1 5.838000n 1 5.840000n 1 5.842000n 1 5.844000n 1 5.846000n 1 5.848000n 1 5.850000n 1 5.852000n 0.992594806 5.854000n 0.984524503 5.856000n 0.976519817 5.858000n 0.968580212 5.860000n 0.960705161 5.862000n 0.952894137 5.864000n 0.945146622 5.866000n 0.937462097 5.868000n 0.929840052 5.870000n 0.922279978 5.872000n 0.914781371 5.874000n 0.907343731 5.876000n 0.899966564 5.878000n 0.892649376 5.880000n 0.885391681 5.882000n 0.878192995 5.884000n 0.871052838 5.886000n 0.863970733 5.888000n 0.85694621 5.890000n 0.8499788 5.892000n 0.843068039 5.894000n 0.836213465 5.896000n 0.829414623 5.898000n 0.822671059 5.900000n 0.815982323 5.902000n 0.80934797 5.904000n 0.802767558 5.906000n 0.796240648 5.908000n 0.789766806 5.910000n 0.783345598 5.912000n 0.776976599 5.914000n 0.770659382 5.916000n 0.764393528 5.918000n 0.758178619 5.920000n 0.75201424 5.922000n 0.74589998 5.924000n 0.739835433 5.926000n 0.733820193 5.928000n 0.72785386 5.930000n 0.721936037 5.932000n 0.716066328 5.934000n 0.710244344 5.936000n 0.704469695 5.938000n 0.698741996 5.940000n 0.693060867 5.942000n 0.687425929 5.944000n 0.681836805 5.946000n 0.676293124 5.948000n 0.670794516 5.950000n 0.665340614 5.952000n 0.659931055 5.954000n 0.654565479 5.956000n 0.649243527 5.958000n 0.643964846 5.960000n 0.638729083 5.962000n 0.63353589 5.964000n 0.628384919 5.966000n 0.623275829 5.968000n 0.618208279 5.970000n 0.61318193 5.972000n 0.608196448 5.974000n 0.6032515 5.976000n 0.598346758 5.978000n 0.593481893 5.980000n 0.588656582 5.982000n 0.583870504 5.984000n 0.579123339 5.986000n 0.57441477 5.988000n 0.569744485 5.990000n 0.565112172 5.992000n 0.560517521 5.994000n 0.555960228 5.996000n 0.551439987 5.998000n 0.546956499 6.000000n 0.542509463 6.002000n 0.538098584 6.004000n 0.533723568 6.006000n 0.529384123 6.008000n 0.52507996 6.010000n 0.520810792 6.012000n 0.516576335 6.014000n 0.512376305 6.016000n 0.508210424 6.018000n 0.504078414 6.020000n 0.499979999 6.022000n 0.495914907 6.024000n 0.491882866 6.026000n 0.487883607 6.028000n 0.483916864 6.030000n 0.479982373 6.032000n 0.476079871 6.034000n 0.472209099 6.036000n 0.468369798 6.038000n 0.464561712 6.040000n 0.460784589 6.042000n 0.457038175 6.044000n 0.453322221 6.046000n 0.44963648 6.048000n 0.445980706 6.050000n 0.442354655 6.052000n 0.438758086 6.054000n 0.435190759 6.056000n 0.431652436 6.058000n 0.428142881 6.060000n 0.424661861 6.062000n 0.421209143 6.064000n 0.417784498 6.066000n 0.414387697 6.068000n 0.411018513 6.070000n 0.407676723 6.072000n 0.404362103 6.074000n 0.401074433 6.076000n 0.397813493 6.078000n 0.394579066 6.080000n 0.391370937 6.082000n 0.388188892 6.084000n 0.385032718 6.086000n 0.381902205 6.088000n 0.378797146 6.090000n 0.375717331 6.092000n 0.372662558 6.094000n 0.369632621 6.096000n 0.366627319 6.098000n 0.363646452 6.100000n 0.360689821 6.102000n 0.357757228 6.104000n 0.354848479 6.106000n 0.35196338 6.108000n 0.349101738 6.110000n 0.346263363 6.112000n 0.343448065 6.114000n 0.340655657 6.116000n 0.337885953 6.118000n 0.335138767 6.120000n 0.332413918 6.122000n 0.329711223 6.124000n 0.327030503 6.126000n 0.324371578 6.128000n 0.321734271 6.130000n 0.319118408 6.132000n 0.316523812 6.134000n 0.313950312 6.136000n 0.311397736 6.138000n 0.308865913 6.140000n 0.306354676 6.142000n 0.303863856 6.144000n 0.301393287 6.146000n 0.298942806 6.148000n 0.296512249 6.150000n 0.294101453 6.152000n 0.291710258 6.154000n 0.289338504 6.156000n 0.286986035 6.158000n 0.284652692 6.160000n 0.28233832 6.162000n 0.280042765 6.164000n 0.277765875 6.166000n 0.275507497 6.168000n 0.27326748 6.170000n 0.271045676 6.172000n 0.268841936 6.174000n 0.266656114 6.176000n 0.264488064 6.178000n 0.262337641 6.180000n 0.260204702 6.182000n 0.258089105 6.184000n 0.255990709 6.186000n 0.253909374 6.188000n 0.251844961 6.190000n 0.249797333 6.192000n 0.247766353 6.194000n 0.245751886 6.196000n 0.243753798 6.198000n 0.241771955 6.200000n 0.239806225 6.202000n 0.237856478 6.204000n 0.235922584 6.206000n 0.234004413 6.208000n 0.232101838 6.210000n 0.230214731 6.212000n 0.228342968 6.214000n 0.226486423 6.216000n 0.224644973 6.218000n 0.222818495 6.220000n 0.221006866 6.222000n 0.219209968 6.224000n 0.217427679 6.226000n 0.215659881 6.228000n 0.213906456 6.230000n 0.212167287 6.232000n 0.210442259 6.234000n 0.208731256 6.236000n 0.207034164 6.238000n 0.205350871 6.240000n 0.203681264 6.242000n 0.202025231 6.244000n 0.200382663 6.246000n 0.198753449 6.248000n 0.197137482 6.250000n 0.195534654 6.252000n 0.193944857 6.254000n 0.192367987 6.256000n 0.190803937 6.258000n 0.189252603 6.260000n 0.187713883 6.262000n 0.186187674 6.264000n 0.184673873 6.266000n 0.18317238 6.268000n 0.181683095 6.270000n 0.180205919 6.272000n 0.178740753 6.274000n 0.177287499 6.276000n 0.175846061 6.278000n 0.174416343 6.280000n 0.172998249 6.282000n 0.171591685 6.284000n 0.170196557 6.286000n 0.168812772 6.288000n 0.167440238 6.290000n 0.166078863 6.292000n 0.164728558 6.294000n 0.16338923 6.296000n 0.162060792 6.298000n 0.160743156 6.300000n 0.159436232 6.302000n 0.158139934 6.304000n 0.156854175 6.306000n 0.155578871 6.308000n 0.154313935 6.310000n 0.153059284 6.312000n 0.151814834 6.314000n 0.150580502 6.316000n 0.149356206 6.318000n 0.148141863 6.320000n 0.146937394 6.322000n 0.145742718 6.324000n 0.144557756 6.326000n 0.143382427 6.328000n 0.142216655 6.330000n 0.141060361 6.332000n 0.139913468 6.334000n 0.1387759 6.336000n 0.137647582 6.338000n 0.136528436 6.340000n 0.135418391 6.342000n 0.13431737 6.344000n 0.133225301 6.346000n 0.132142111 6.348000n 0.131067729 6.350000n 0.130002081 6.352000n 0.128945098 6.354000n 0.127896708 6.356000n 0.126856843 6.358000n 0.125825432 6.360000n 0.124802407 6.362000n 0.1237877 6.364000n 0.122781243 6.366000n 0.121782968 6.368000n 0.120792811 6.370000n 0.119810704 6.372000n 0.118836581 6.374000n 0.117870379 6.376000n 0.116912033 6.378000n 0.115961478 6.380000n 0.115018652 6.382000n 0.114083492 6.384000n 0.113155935 6.386000n 0.11223592 6.388000n 0.111323384 6.390000n 0.110418268 6.392000n 0.109520511 6.394000n 0.108630054 6.396000n 0.107746836 6.398000n 0.106870799 6.400000n 0.106001885 6.402000n 0.105140036 6.404000n 0.104285193 6.406000n 0.103437302 6.408000n 0.102596304 6.410000n 0.101762143 6.412000n 0.100934765 6.414000n 0.100114114 6.416000n 0.0993001351 6.418000n 0.0984927743 6.420000n 0.0976919778 6.422000n 0.0968976921 6.424000n 0.0961098645 6.426000n 0.0953284422 6.428000n 0.0945533733 6.430000n 0.0937846061 6.432000n 0.0930220894 6.434000n 0.0922657723 6.436000n 0.0915156045 6.438000n 0.0907715359 6.440000n 0.090033517 6.442000n 0.0893014986 6.444000n 0.0885754318 6.446000n 0.0878552683 6.448000n 0.0871409602 6.450000n 0.0864324597 6.452000n 0.0857297197 6.454000n 0.0850326933 6.456000n 0.0843413341 6.458000n 0.083655596 6.460000n 0.0829754333 6.462000n 0.0823008007 6.464000n 0.0816316532 6.466000n 0.0809679462 6.468000n 0.0803096354 6.470000n 0.0796566771 6.472000n 0.0790090277 6.474000n 0.078366644 6.476000n 0.0777294831 6.478000n 0.0770975028 6.480000n 0.0764706607 6.482000n 0.0758489152 6.484000n 0.0752322248 6.486000n 0.0746205484 6.488000n 0.0740138453 6.490000n 0.073412075 6.492000n 0.0728151973 6.494000n 0.0722231726 6.496000n 0.0716359613 6.498000n 0.0710535244 6.500000n 0.070475823 6.502000n 0.0699028186 6.504000n 0.069334473 6.506000n 0.0687707483 6.508000n 0.068211607 6.510000n 0.0676570119 6.512000n 0.0671069258 6.514000n 0.0665613123 6.516000n 0.0660201348 6.518000n 0.0654833574 6.520000n 0.0649509443 6.522000n 0.06442286 6.524000n 0.0638990693 6.526000n 0.0633795372 6.528000n 0.0628642292 6.530000n 0.0623531109 6.532000n 0.0618461483 6.534000n 0.0613433076 6.536000n 0.0608445552 6.538000n 0.0603498579 6.540000n 0.0598591827 6.542000n 0.059372497 6.544000n 0.0588897683 6.546000n 0.0584109645 6.548000n 0.0579360535 6.550000n 0.0574650038 6.552000n 0.056997784 6.554000n 0.0565343629 6.556000n 0.0560747097 6.558000n 0.0556187937 6.560000n 0.0551665845 6.562000n 0.054718052 6.564000n 0.0542731663 6.566000n 0.0538318978 6.568000n 0.053394217 6.570000n 0.0529600947 6.572000n 0.0525295021 6.574000n 0.0521024105 6.576000n 0.0516787913 6.578000n 0.0512586163 6.580000n 0.0508418576 6.582000n 0.0504284874 6.584000n 0.050018478 6.586000n 0.0496118023 6.588000n 0.049208433 6.590000n 0.0488083433 6.592000n 0.0484115066 6.594000n 0.0480178963 6.596000n 0.0476274863 6.598000n 0.0472402505 6.600000n 0.0468561632 6.602000n 0.0464751987 6.604000n 0.0460973316 6.606000n 0.0457225368 6.608000n 0.0453507892 6.610000n 0.0449820641 6.612000n 0.044616337 6.614000n 0.0442535834 6.616000n 0.0438937792 6.618000n 0.0435369004 6.620000n 0.0431829231 6.622000n 0.0428318239 6.624000n 0.0424835793 6.626000n 0.0421381662 6.628000n 0.0417955614 6.630000n 0.0414557421 6.632000n 0.0411186858 6.634000n 0.0407843699 6.636000n 0.0404527721 6.638000n 0.0401238704 6.640000n 0.0397976429 6.642000n 0.0394740677 6.644000n 0.0391531234 6.646000n 0.0388347885 6.648000n 0.0385190419 6.650000n 0.0382058624 6.652000n 0.0378952293 6.654000n 0.0375871217 6.656000n 0.0372815192 6.658000n 0.0369784014 6.660000n 0.0366777482 6.662000n 0.0363795393 6.664000n 0.0360837551 6.666000n 0.0357903758 6.668000n 0.0354993818 6.670000n 0.0352107537 6.672000n 0.0349244723 6.674000n 0.0346405185 6.676000n 0.0343588734 6.678000n 0.0340795182 6.680000n 0.0338024343 6.682000n 0.0335276033 6.684000n 0.0332550068 6.686000n 0.0329846266 6.688000n 0.0327164447 6.690000n 0.0324504433 6.692000n 0.0321866047 6.694000n 0.0319249111 6.696000n 0.0316653453 6.698000n 0.0314078899 6.700000n 0.0311525277 6.702000n 0.0308992418 6.704000n 0.0306480152 6.706000n 0.0303988312 6.708000n 0.0301516732 6.710000n 0.0299065247 6.712000n 0.0296633693 6.714000n 0.029422191 6.716000n 0.0291829736 6.718000n 0.0289457011 6.720000n 0.0287103578 6.722000n 0.0284769279 6.724000n 0.028245396 6.726000n 0.0280157465 6.728000n 0.0277879642 6.730000n 0.0275620338 6.732000n 0.0273379404 6.734000n 0.027115669 6.736000n 0.0268952048 6.738000n 0.0266765331 6.740000n 0.0264596392 6.742000n 0.0262445088 6.744000n 0.0260311276 6.746000n 0.0258194812 6.748000n 0.0256095557 6.750000n 0.0254013369 6.752000n 0.0251948111 6.754000n 0.0249899644 6.756000n 0.0247867833 6.758000n 0.0245852541 6.760000n 0.0243853634 6.762000n 0.0241870979 6.764000n 0.0239904445 6.766000n 0.0237953899 6.768000n 0.0236019213 6.770000n 0.0234100256 6.772000n 0.0232196901 6.774000n 0.0230309022 6.776000n 0.0228436492 6.778000n 0.0226579187 6.780000n 0.0224736982 6.782000n 0.0222909756 6.784000n 0.0221097386 6.786000n 0.0219299751 6.788000n 0.0217516732 6.790000n 0.021574821 6.792000n 0.0213994067 6.794000n 0.0212254186 6.796000n 0.0210528451 6.798000n 0.0208816748 6.800000n 0.0207118961 6.802000n 0.0205434978 6.804000n 0.0203764687 6.806000n 0.0202107976 6.808000n 0.0200464735 6.810000n 0.0198834854 6.812000n 0.0197218226 6.814000n 0.0195614741 6.816000n 0.0194024293 6.818000n 0.0192446776 6.820000n 0.0190882086 6.822000n 0.0189330117 6.824000n 0.0187790767 6.826000n 0.0186263932 6.828000n 0.0184749511 6.830000n 0.0183247403 6.832000n 0.0181757508 6.834000n 0.0180279727 6.836000n 0.0178813961 6.838000n 0.0177360112 6.840000n 0.0175918084 6.842000n 0.017448778 6.844000n 0.0173069105 6.846000n 0.0171661965 6.848000n 0.0170266266 6.850000n 0.0168881914 6.852000n 0.0167508818 6.854000n 0.0166146886 6.856000n 0.0164796027 6.858000n 0.0163456151 6.860000n 0.0162127169 6.862000n 0.0160808992 6.864000n 0.0159501533 6.866000n 0.0158204704 6.868000n 0.0156918419 6.870000n 0.0155642592 6.872000n 0.0154377139 6.874000n 0.0153121974 6.876000n 0.0151877014 6.878000n 0.0150642176 6.880000n 0.0149417379 6.882000n 0.0148202539 6.884000n 0.0146997577 6.886000n 0.0145802411 6.888000n 0.0144616963 6.890000n 0.0143441154 6.892000n 0.0142274904 6.894000n 0.0141118136 6.896000n 0.0139970774 6.898000n 0.013883274 6.900000n 0.0137703959 6.902000n 0.0136584356 6.904000n 0.0135473855 6.906000n 0.0134372383 6.908000n 0.0133279867 6.910000n 0.0132196234 6.912000n 0.0131121411 6.914000n 0.0130055327 6.916000n 0.0128997911 6.918000n 0.0127949092 6.920000n 0.0126908801 6.922000n 0.0125876967 6.924000n 0.0124853523 6.926000n 0.01238384 6.928000n 0.0122831531 6.930000n 0.0121832848 6.932000n 0.0120842285 6.934000n 0.0119859775 6.936000n 0.0118885254 6.938000n 0.0117918656 6.940000n 0.0116959918 6.942000n 0.0116008974 6.944000n 0.0115065762 6.946000n 0.0114130218 6.948000n 0.0113202281 6.950000n 0.0112281889 6.952000n 0.011136898 6.954000n 0.0110463493 6.956000n 0.0109565369 6.958000n 0.0108674546 6.960000n 0.0107790967 6.962000n 0.0106914571 6.964000n 0.0106045301 6.966000n 0.0105183099 6.968000n 0.0104327906 6.970000n 0.0103479667 6.972000n 0.0102638325 6.974000n 0.0101803823 6.976000n 0.0100976106 6.978000n 0.0100155118 6.980000n 0.00993408063 6.982000n 0.00985331148 6.984000n 0.00977319903 6.986000n 0.00969373793 6.988000n 0.00961492289 6.990000n 0.00953674866 6.992000n 0.00945921003 6.994000n 0.00938230182 6.996000n 0.00930601892 6.998000n 0.00923035624 7.000000n 0.00915530873 7.002000n 0.0090808714 7.004000n 0.00900703928 7.006000n 0.00893380745 7.008000n 0.00886117104 7.010000n 0.00878912519 7.012000n 0.00871766512 7.014000n 0.00864678605 7.016000n 0.00857648327 7.018000n 0.00850675208 7.020000n 0.00843758785 7.022000n 0.00836898595 7.024000n 0.00830094182 7.026000n 0.00823345093 7.028000n 0.00816650877 7.030000n 0.00810011089 7.032000n 0.00803425285 7.034000n 0.00796893027 7.036000n 0.0079041388 7.038000n 0.00783987412 7.040000n 0.00777613194 7.042000n 0.00771290802 7.044000n 0.00765019814 7.046000n 0.00758799813 7.048000n 0.00752630383 7.050000n 0.00746511114 7.052000n 0.00740441597 7.054000n 0.00734421429 7.056000n 0.00728450208 7.058000n 0.00722527536 7.060000n 0.00716653019 7.062000n 0.00710826264 7.064000n 0.00705046883 7.066000n 0.00699314492 7.068000n 0.00693628709 7.070000n 0.00687989153 7.072000n 0.0068239545 7.074000n 0.00676847227 7.076000n 0.00671344114 7.078000n 0.00665885743 7.080000n 0.00660471752 7.082000n 0.0065510178 7.084000n 0.00649775468 7.086000n 0.00644492462 7.088000n 0.00639252409 7.090000n 0.00634054961 7.092000n 0.0062889977 7.094000n 0.00623786494 7.096000n 0.00618714792 7.098000n 0.00613684325 7.100000n 0.00608694758 7.102000n 0.00603745759 7.104000n 0.00598836998 7.106000n 0.00593968147 7.108000n 0.00589138883 7.110000n 0.00584348883 7.112000n 0.00579597828 7.114000n 0.00574885402 7.116000n 0.0057021129 7.118000n 0.00565575182 7.120000n 0.00560976767 7.122000n 0.00556415739 7.124000n 0.00551891795 7.126000n 0.00547404633 7.128000n 0.00542953954 7.130000n 0.00538539462 7.132000n 0.00534160861 7.134000n 0.0052981786 7.136000n 0.00525510171 7.138000n 0.00521237505 7.140000n 0.00516999578 7.142000n 0.00512796107 7.144000n 0.00508626813 7.146000n 0.00504491418 7.148000n 0.00500389645 7.150000n 0.00496321222 7.152000n 0.00492285877 7.154000n 0.00488283342 7.156000n 0.00484313349 7.158000n 0.00480375634 7.160000n 0.00476469935 7.162000n 0.00472595991 7.164000n 0.00468753545 7.166000n 0.00464942339 7.168000n 0.0046116212 7.170000n 0.00457412637 7.172000n 0.00453693639 7.174000n 0.00450004878 7.176000n 0.00446346109 7.178000n 0.00442717087 7.180000n 0.00439117571 7.182000n 0.00435547321 7.184000n 0.00432006099 7.186000n 0.00428493669 7.188000n 0.00425009797 7.190000n 0.0042155425 7.192000n 0.00418126799 7.194000n 0.00414727215 7.196000n 0.00411355271 7.198000n 0.00408010742 7.200000n 0.00404693407 7.202000n 0.00401403043 7.204000n 0.00398139431 7.206000n 0.00394902355 7.208000n 0.00391691597 7.210000n 0.00388506944 7.212000n 0.00385348184 7.214000n 0.00382215107 7.216000n 0.00379107503 7.218000n 0.00376025166 7.220000n 0.00372967889 7.222000n 0.0036993547 7.224000n 0.00366927706 7.226000n 0.00363944396 7.228000n 0.00360985342 7.230000n 0.00358050347 7.232000n 0.00355139215 7.234000n 0.00352251752 7.236000n 0.00349387766 7.238000n 0.00346547065 7.240000n 0.0034372946 7.242000n 0.00340934764 7.244000n 0.00338162791 7.246000n 0.00335413355 7.248000n 0.00332686273 7.250000n 0.00329981364 7.252000n 0.00327298447 7.254000n 0.00324637343 7.256000n 0.00321997876 7.258000n 0.00319379869 7.260000n 0.00316783148 7.262000n 0.00314207539 7.264000n 0.00311652871 7.266000n 0.00309118974 7.268000n 0.00306605679 7.270000n 0.00304112819 7.272000n 0.00301640226 7.274000n 0.00299187737 7.276000n 0.00296755188 7.278000n 0.00294342417 7.280000n 0.00291949263 7.282000n 0.00289575566 7.284000n 0.00287221169 7.286000n 0.00284885915 7.288000n 0.00282569647 7.290000n 0.00280272211 7.292000n 0.00277993455 7.294000n 0.00275733226 7.296000n 0.00273491375 7.298000n 0.0027126775 7.300000n 0.00269062205 7.302000n 0.00266874592 7.304000n 0.00264704765 7.306000n 0.0026255258 7.308000n 0.00260417894 7.310000n 0.00258300563 7.312000n 0.00256200448 7.314000n 0.00254117408 7.316000n 0.00252051303 7.318000n 0.00250001998 7.320000n 0.00247969354 7.322000n 0.00245953236 7.324000n 0.00243953511 7.326000n 0.00241970044 7.328000n 0.00240002704 7.330000n 0.0023805136 7.332000n 0.00236115881 7.334000n 0.00234196138 7.336000n 0.00232292004 7.338000n 0.00230403352 7.340000n 0.00228530055 7.342000n 0.00226671989 7.344000n 0.0022482903 7.346000n 0.00223001055 7.348000n 0.00221187943 7.350000n 0.00219389572 7.352000n 0.00217605823 7.354000n 0.00215836576 7.356000n 0.00214081715 7.358000n 0.00212341121 7.360000n 0.00210614679 7.362000n 0.00208902275 7.364000n 0.00207203792 7.366000n 0.0020551912 7.368000n 0.00203848144 7.370000n 0.00202190755 7.372000n 0.00200546841 7.374000n 0.00198916293 7.376000n 0.00197299002 7.378000n 0.0019569486 7.380000n 0.00194103761 7.382000n 0.00192525598 7.384000n 0.00190960267 7.386000n 0.00189407663 7.388000n 0.00187867682 7.390000n 0.00186340222 7.392000n 0.0018482518 7.394000n 0.00183322457 7.396000n 0.00181831952 7.398000n 0.00180353566 7.400000n 0.00178887199 7.402000n 0.00177432755 7.404000n 0.00175990136 7.406000n 0.00174559246 7.408000n 0.00173139991 7.410000n 0.00171732274 7.412000n 0.00170336003 7.414000n 0.00168951084 7.416000n 0.00167577426 7.418000n 0.00166214936 7.420000n 0.00164863524 7.422000n 0.00163523099 7.424000n 0.00162193573 7.426000n 0.00160874856 7.428000n 0.00159566862 7.430000n 0.00158269502 7.432000n 0.0015698269 7.434000n 0.0015570634 7.436000n 0.00154440368 7.438000n 0.00153184689 7.440000n 0.0015193922 7.442000n 0.00150703876 7.444000n 0.00149478577 7.446000n 0.0014826324 7.448000n 0.00147057784 7.450000n 0.00145862129 7.452000n 0.00144676195 7.454000n 0.00143499904 7.456000n 0.00142333177 7.458000n 0.00141175935 7.460000n 0.00140028103 7.462000n 0.00138889603 7.464000n 0.0013776036 7.466000n 0.00136640297 7.468000n 0.00135529342 7.470000n 0.00134427419 7.472000n 0.00133334456 7.474000n 0.00132250379 7.476000n 0.00131175116 7.478000n 0.00130108595 7.480000n 0.00129050746 7.482000n 0.00128001497 7.484000n 0.0012696078 7.486000n 0.00125928524 7.488000n 0.00124904661 7.490000n 0.00123889122 7.492000n 0.0012288184 7.494000n 0.00121882748 7.496000n 0.00120891779 7.498000n 0.00119908867 7.500000n 0.00118933947 7.502000n 0.00117966953 7.504000n 0.00117007822 7.506000n 0.00116056488 7.508000n 0.0011511289 7.510000n 0.00114176963 7.512000n 0.00113248646 7.514000n 0.00112327877 7.516000n 0.00111414594 7.518000n 0.00110508737 7.520000n 0.00109610244 7.522000n 0.00108719057 7.524000n 0.00107835116 7.526000n 0.00106958361 7.528000n 0.00106088735 7.530000n 0.00105226179 7.532000n 0.00104370637 7.534000n 0.0010352205 7.536000n 0.00102680363 7.538000n 0.00101845519 7.540000n 0.00101017463 7.542000n 0.0010019614 7.544000n 0.000993814941 7.546000n 0.000985734718 7.548000n 0.000977720192 7.550000n 0.000969770827 7.552000n 0.000961886096 7.554000n 0.000954065471 7.556000n 0.000946308432 7.558000n 0.000938614461 7.560000n 0.000930983046 7.562000n 0.000923413679 7.564000n 0.000915905854 7.566000n 0.000908459072 7.568000n 0.000901072836 7.570000n 0.000893746654 7.572000n 0.000886480038 7.574000n 0.000879272503 7.576000n 0.000872123569 7.578000n 0.000865032759 7.580000n 0.000857999601 7.582000n 0.000851023626 7.584000n 0.00084410437 7.586000n 0.00083724137 7.588000n 0.000830434171 7.590000n 0.000823682317 7.592000n 0.000816985359 7.594000n 0.000810342851 7.596000n 0.000803754351 7.598000n 0.000797219417 7.600000n 0.000790737617 7.602000n 0.000784308516 7.604000n 0.000777931688 7.606000n 0.000771606706 7.608000n 0.00076533315 7.610000n 0.000759110601 7.612000n 0.000752938644 7.614000n 0.000746816868 7.616000n 0.000740744866 7.618000n 0.000734722232 7.620000n 0.000728748565 7.622000n 0.000722823468 7.624000n 0.000716946544 7.626000n 0.000711117403 7.628000n 0.000705335655 7.630000n 0.000699600916 7.632000n 0.000693912804 7.634000n 0.000688270939 7.636000n 0.000682674945 7.638000n 0.000677124449 7.640000n 0.000671619081 7.642000n 0.000666158475 7.644000n 0.000660742267 7.646000n 0.000655370095 7.648000n 0.000650041602 7.650000n 0.000644756432 7.652000n 0.000639514233 7.654000n 0.000634314656 7.656000n 0.000629157354 7.658000n 0.000624041983 7.660000n 0.000618968204 7.662000n 0.000613935676 7.664000n 0.000608944066 7.666000n 0.00060399304 7.668000n 0.000599082268 7.670000n 0.000594211423 7.672000n 0.000589380181 7.674000n 0.00058458822 7.676000n 0.000579835219 7.678000n 0.000575120863 7.680000n 0.000570444837 7.682000n 0.000565806829 7.684000n 0.000561206531 7.686000n 0.000556643635 7.688000n 0.000552117838 7.690000n 0.000547628838 7.692000n 0.000543176336 7.694000n 0.000538760036 7.696000n 0.000534379641 7.698000n 0.000530034862 7.700000n 0.000525725408 7.702000n 0.000521450992 7.704000n 0.00051721133 7.706000n 0.000513006138 7.708000n 0.000508835136 7.710000n 0.000504698046 7.712000n 0.000500594594 7.714000n 0.000496524504 7.716000n 0.000492487507 7.718000n 0.000488483332 7.720000n 0.000484511713 7.722000n 0.000480572385 7.724000n 0.000476665087 7.726000n 0.000472789556 7.728000n 0.000468945536 7.730000n 0.000465132769 7.732000n 0.000461351002 7.734000n 0.000457599983 7.736000n 0.000453879462 7.738000n 0.00045018919 7.740000n 0.000446528922 7.742000n 0.000442898414 7.744000n 0.000439297424 7.746000n 0.000435725712 7.748000n 0.000432183039 7.750000n 0.000428669171 7.752000n 0.000425183872 7.754000n 0.00042172691 7.756000n 0.000418298055 7.758000n 0.000414897078 7.760000n 0.000411523753 7.762000n 0.000408177855 7.764000n 0.00040485916 7.766000n 0.000401567449 7.768000n 0.000398302501 7.770000n 0.000395064098 7.772000n 0.000391852025 7.774000n 0.000388666068 7.776000n 0.000385506015 7.778000n 0.000382371654 7.780000n 0.000379262777 7.782000n 0.000376179177 7.784000n 0.000373120649 7.786000n 0.000370086987 7.788000n 0.000367077991 7.790000n 0.00036409346 7.792000n 0.000361133194 7.794000n 0.000358196997 7.796000n 0.000355284673 7.798000n 0.000352396027 7.800000n 0.000349530867 7.802000n 0.000346689003 7.804000n 0.000343870244 7.806000n 0.000341074404 7.808000n 0.000338301295 7.810000n 0.000335550733 7.812000n 0.000332822534 7.814000n 0.000330116517 7.816000n 0.000327432501 7.818000n 0.000324770308 7.820000n 0.000322129759 7.822000n 0.00031951068 7.824000n 0.000316912895 7.826000n 0.000314336231 7.828000n 0.000311780517 7.830000n 0.000309245583 7.832000n 0.000306731258 7.834000n 0.000304237377 7.836000n 0.000301763771 7.838000n 0.000299310278 7.840000n 0.000296876733 7.842000n 0.000294462973 7.844000n 0.000292068839 7.846000n 0.00028969417 7.848000n 0.000287338809 7.850000n 0.000285002598 7.852000n 0.000282685381 7.854000n 0.000280387005 7.856000n 0.000278107315 7.858000n 0.000275846161 7.860000n 0.000273603391 7.862000n 0.000271378855 7.864000n 0.000269172407 7.866000n 0.000266983898 7.868000n 0.000264813182 7.870000n 0.000262660116 7.872000n 0.000260524555 7.874000n 0.000258406358 7.876000n 0.000256305382 7.878000n 0.000254221488 7.880000n 0.000252154538 7.882000n 0.000250104393 7.884000n 0.000248070917 7.886000n 0.000246053973 7.888000n 0.000244053429 7.890000n 0.00024206915 7.892000n 0.000240101004 7.894000n 0.000238148861 7.896000n 0.000236212589 7.898000n 0.00023429206 7.900000n 0.000232387146 7.902000n 0.00023049772 7.904000n 0.000228623656 7.906000n 0.000226764829 7.908000n 0.000224921115 7.910000n 0.000223092391 7.912000n 0.000221278536 7.914000n 0.000219479429 7.916000n 0.000217694949 7.918000n 0.000215924978 7.920000n 0.000214169398 7.922000n 0.000212428091 7.924000n 0.000210700943 7.926000n 0.000208987836 7.928000n 0.000207288659 7.930000n 0.000205603296 7.932000n 0.000203931636 7.934000n 0.000202273568 7.936000n 0.000200628981 7.938000n 0.000198997765 7.940000n 0.000197379811 7.942000n 0.000195775013 7.944000n 0.000194183262 7.946000n 0.000192604453 7.948000n 0.00019103848 7.950000n 0.00018948524 7.952000n 0.000187944628 7.954000n 0.000186416542 7.956000n 0.000184900881 7.958000n 0.000183397542 7.960000n 0.000181906427 7.962000n 0.000180427435 7.964000n 0.000178960467 7.966000n 0.000177505427 7.968000n 0.000176062218 7.970000n 0.000174630742 7.972000n 0.000173210905 7.974000n 0.000171802612 7.976000n 0.000170405769 7.978000n 0.000169020283 7.980000n 0.000167646062 7.982000n 0.000166283014 7.984000n 0.000164931048 7.986000n 0.000163590074 7.988000n 0.000162260004 7.990000n 0.000160940747 7.992000n 0.000159632217 7.994000n 0.000158334325 7.996000n 0.000157046986 7.998000n 0.000155770114 8.000000n 0.000154503624 8.002000n 0.00015324743 8.004000n 0.000152001451 8.006000n 0.000150765601 8.008000n 0.0001495398 8.010000n 0.000148323965 8.012000n 0.000147118015 8.014000n 0.000145921871 8.016000n 0.000144735452 8.018000n 0.000143558678 8.020000n 0.000142391473 8.022000n 0.000141233758 8.024000n 0.000140085455 8.026000n 0.000138946489 8.028000n 0.000137816783 8.030000n 0.000136696262 8.032000n 0.000135584852 8.034000n 0.000134482478 8.036000n 0.000133389067 8.038000n 0.000132304546 8.040000n 0.000131228842 8.042000n 0.000130161885 8.044000n 0.000129103602 8.046000n 0.000128053924 8.048000n 0.00012701278 8.050000n 0.000125980101 8.052000n 0.000124955819 8.054000n 0.000123939864 8.056000n 0.00012293217 8.058000n 0.000121932669 8.060000n 0.000120941294 8.062000n 0.000119957979 8.064000n 0.00011898266 8.066000n 0.00011801527 8.068000n 0.000117055746 8.070000n 0.000116104023 8.072000n 0.000115160038 8.074000n 0.000114223728 8.076000n 0.000113295031 8.078000n 0.000112373884 8.080000n 0.000111460227 8.082000n 0.000110553999 8.084000n 0.000109655138 8.086000n 0.000108763586 8.088000n 0.000107879282 8.090000n 0.000107002169 8.092000n 0.000106132187 8.094000n 0.000105269278 8.096000n 0.000104413385 8.098000n 0.000103564451 8.100000n 0.000102722419 8.102000n 0.000101887233 8.104000n 0.000101058838 8.106000n 0.000100237178 8.108000n 9.94221986e-05 8.110000n 9.86138453e-05 8.112000n 9.78120644e-05 8.114000n 9.70168024e-05 8.116000n 9.62280063e-05 8.118000n 9.54456235e-05 8.120000n 9.46696019e-05 8.122000n 9.38998897e-05 8.124000n 9.31364357e-05 8.126000n 9.23791889e-05 8.128000n 9.16280989e-05 8.130000n 9.08831157e-05 8.132000n 9.01441896e-05 8.134000n 8.94112713e-05 8.136000n 8.86843121e-05 8.138000n 8.79632634e-05 8.140000n 8.72480771e-05 8.142000n 8.65387057e-05 8.144000n 8.58351019e-05 8.146000n 8.51372187e-05 8.148000n 8.44450096e-05 8.150000n 8.37584286e-05 8.152000n 8.30774298e-05 8.154000n 8.24019679e-05 8.156000n 8.17319979e-05 8.158000n 8.1067475e-05 8.160000n 8.04083551e-05 8.162000n 7.97545941e-05 8.164000n 7.91061485e-05 8.166000n 7.84629752e-05 8.168000n 7.78250311e-05 8.170000n 7.71922739e-05 8.172000n 7.65646613e-05 8.174000n 7.59421516e-05 8.176000n 7.53247031e-05 8.178000n 7.47122748e-05 8.180000n 7.41048259e-05 8.182000n 7.35023158e-05 8.184000n 7.29047045e-05 8.186000n 7.2311952e-05 8.188000n 7.1724019e-05 8.190000n 7.11408661e-05 8.192000n 7.05624545e-05 8.194000n 6.99887458e-05 8.196000n 6.94197015e-05 8.198000n 6.88552839e-05 8.200000n 6.82954553e-05 8.202000n 6.77401784e-05 8.204000n 6.71894162e-05 8.206000n 6.66431319e-05 8.208000n 6.61012893e-05 8.210000n 6.5563852e-05 8.212000n 6.50307845e-05 8.214000n 6.4502051e-05 8.216000n 6.39776164e-05 8.218000n 6.34574457e-05 8.220000n 6.29415043e-05 8.222000n 6.24297577e-05 8.224000n 6.19221719e-05 8.226000n 6.14187131e-05 8.228000n 6.09193476e-05 8.230000n 6.04240422e-05 8.232000n 5.99327639e-05 8.234000n 5.94454799e-05 8.236000n 5.89621579e-05 8.238000n 5.84827654e-05 8.240000n 5.80072707e-05 8.242000n 5.7535642e-05 8.244000n 5.70678478e-05 8.246000n 5.66038571e-05 8.248000n 5.61436388e-05 8.250000n 5.56871624e-05 8.252000n 5.52343974e-05 8.254000n 5.47853135e-05 8.256000n 5.4339881e-05 8.258000n 5.389807e-05 8.260000n 5.34598512e-05 8.262000n 5.30251953e-05 8.264000n 5.25940734e-05 8.266000n 5.21664567e-05 8.268000n 5.17423168e-05 8.270000n 5.13216254e-05 8.272000n 5.09043544e-05 8.274000n 5.0490476e-05 8.276000n 5.00799626e-05 8.278000n 4.9672787e-05 8.280000n 4.92689219e-05 8.282000n 4.88683404e-05 8.284000n 4.84710158e-05 8.286000n 4.80769217e-05 8.288000n 4.76860318e-05 8.290000n 4.729832e-05 8.292000n 4.69137606e-05 8.294000n 4.65323277e-05 8.296000n 4.61539962e-05 8.298000n 4.57787406e-05 8.300000n 4.54065361e-05 8.302000n 4.50373578e-05 8.304000n 4.46711811e-05 8.306000n 4.43079816e-05 8.308000n 4.39477351e-05 8.310000n 4.35904175e-05 8.312000n 4.32360052e-05 8.314000n 4.28844744e-05 8.316000n 4.25358018e-05 8.318000n 4.2189964e-05 8.320000n 4.1846938e-05 8.322000n 4.15067011e-05 8.324000n 4.11692304e-05 8.326000n 4.08345035e-05 8.328000n 4.05024982e-05 8.330000n 4.01731922e-05 8.332000n 3.98465636e-05 8.334000n 3.95225907e-05 8.336000n 3.92012519e-05 8.338000n 3.88825257e-05 8.340000n 3.85663909e-05 8.342000n 3.82528265e-05 8.344000n 3.79418115e-05 8.346000n 3.76333252e-05 8.348000n 3.73273471e-05 8.350000n 3.70238567e-05 8.352000n 3.67228338e-05 8.354000n 3.64242584e-05 8.356000n 3.61281106e-05 8.358000n 3.58343707e-05 8.360000n 3.55430189e-05 8.362000n 3.5254036e-05 8.364000n 3.49674027e-05 8.366000n 3.46830999e-05 8.368000n 3.44011086e-05 8.370000n 3.412141e-05 8.372000n 3.38439856e-05 8.374000n 3.35688167e-05 8.376000n 3.32958851e-05 8.378000n 3.30251725e-05 8.380000n 3.2756661e-05 8.382000n 3.24903326e-05 8.384000n 3.22261697e-05 8.386000n 3.19641544e-05 8.388000n 3.17042696e-05 8.390000n 3.14464977e-05 8.392000n 3.11908216e-05 8.394000n 3.09372243e-05 8.396000n 3.06856889e-05 8.398000n 3.04361986e-05 8.400000n 3.01887367e-05 8.402000n 2.99432869e-05 8.404000n 2.96998327e-05 8.406000n 2.94583579e-05 8.408000n 2.92188464e-05 8.410000n 2.89812823e-05 8.412000n 2.87456496e-05 8.414000n 2.85119328e-05 8.416000n 2.82801163e-05 8.418000n 2.80501845e-05 8.420000n 2.78221222e-05 8.422000n 2.75959141e-05 8.424000n 2.73715453e-05 8.426000n 2.71490006e-05 8.428000n 2.69282654e-05 8.430000n 2.67093248e-05 8.432000n 2.64921644e-05 8.434000n 2.62767696e-05 8.436000n 2.6063126e-05 8.438000n 2.58512195e-05 8.440000n 2.56410359e-05 8.442000n 2.54325612e-05 8.444000n 2.52257815e-05 8.446000n 2.5020683e-05 8.448000n 2.48172521e-05 8.450000n 2.46154752e-05 8.452000n 2.44153388e-05 8.454000n 2.42168296e-05 8.456000n 2.40199344e-05 8.458000n 2.38246401e-05 8.460000n 2.36309336e-05 8.462000n 2.34388021e-05 8.464000n 2.32482327e-05 8.466000n 2.30592127e-05 8.468000n 2.28717295e-05 8.470000n 2.26857707e-05 8.472000n 2.25013238e-05 8.474000n 2.23183765e-05 8.476000n 2.21369167e-05 8.478000n 2.19569323e-05 8.480000n 2.17784112e-05 8.482000n 2.16013416e-05 8.484000n 2.14257117e-05 8.486000n 2.12515097e-05 8.488000n 2.10787241e-05 8.490000n 2.09073433e-05 8.492000n 2.07373559e-05 8.494000n 2.05687507e-05 8.496000n 2.04015162e-05 8.498000n 2.02356415e-05 8.500000n 2.00711154e-05 8.502000n 1.9907927e-05 8.504000n 1.97460654e-05 8.506000n 1.95855198e-05 8.508000n 1.94262795e-05 8.510000n 1.92683339e-05 8.512000n 1.91116725e-05 8.514000n 1.89562849e-05 8.516000n 1.88021606e-05 8.518000n 1.86492895e-05 8.520000n 1.84976612e-05 8.522000n 1.83472658e-05 8.524000n 1.81980932e-05 8.526000n 1.80501334e-05 8.528000n 1.79033766e-05 8.530000n 1.7757813e-05 8.532000n 1.76134329e-05 8.534000n 1.74702267e-05 8.536000n 1.73281848e-05 8.538000n 1.71872978e-05 8.540000n 1.70475563e-05 8.542000n 1.6908951e-05 8.544000n 1.67714726e-05 8.546000n 1.6635112e-05 8.548000n 1.649986e-05 8.550000n 1.63657077e-05 8.552000n 1.62326462e-05 8.554000n 1.61006665e-05 8.556000n 1.59697598e-05 8.558000n 1.58399176e-05 8.560000n 1.57111309e-05 8.562000n 1.55833914e-05 8.564000n 1.54566905e-05 8.566000n 1.53310197e-05 8.568000n 1.52063707e-05 8.570000n 1.50827351e-05 8.572000n 1.49601048e-05 8.574000n 1.48384715e-05 8.576000n 1.47178272e-05 8.578000n 1.45981637e-05 8.580000n 1.44794732e-05 8.582000n 1.43617477e-05 8.584000n 1.42449794e-05 8.586000n 1.41291604e-05 8.588000n 1.40142831e-05 8.590000n 1.39003398e-05 8.592000n 1.3787323e-05 8.594000n 1.3675225e-05 8.596000n 1.35640385e-05 8.598000n 1.34537559e-05 8.600000n 1.334437e-05 8.602000n 1.32358735e-05 8.604000n 1.31282591e-05 8.606000n 1.30215196e-05 8.608000n 1.2915648e-05 8.610000n 1.28106372e-05 8.612000n 1.27064802e-05 8.614000n 1.260317e-05 8.616000n 1.25006998e-05 8.618000n 1.23990627e-05 8.620000n 1.2298252e-05 8.622000n 1.2198261e-05 8.624000n 1.20990829e-05 8.626000n 1.20007111e-05 8.628000n 1.19031392e-05 8.630000n 1.18063606e-05 8.632000n 1.17103689e-05 8.634000n 1.16151576e-05 8.636000n 1.15207205e-05 8.638000n 1.14270511e-05 8.640000n 1.13341434e-05 8.642000n 1.1241991e-05 8.644000n 1.11505879e-05 8.646000n 1.10599279e-05 8.648000n 1.09700051e-05 8.650000n 1.08808133e-05 8.652000n 1.07923467e-05 8.654000n 1.07045995e-05 8.656000n 1.06175656e-05 8.658000n 1.05312394e-05 8.660000n 1.0445615e-05 8.662000n 1.03606868e-05 8.664000n 1.02764492e-05 8.666000n 1.01928964e-05 8.668000n 1.01100229e-05 8.670000n 1.00278233e-05 8.672000n 9.94629197e-06 8.674000n 9.86542354e-06 8.676000n 9.78521261e-06 8.678000n 9.70565384e-06 8.680000n 9.62674192e-06 8.682000n 9.54847159e-06 8.684000n 9.47083765e-06 8.686000n 9.3938349e-06 8.688000n 9.31745823e-06 8.690000n 9.24170254e-06 8.692000n 9.16656278e-06 8.694000n 9.09203395e-06 8.696000n 9.01811107e-06 8.698000n 8.94478922e-06 8.700000n 8.87206352e-06 8.702000n 8.79992912e-06 8.704000n 8.7283812e-06 8.706000n 8.65741501e-06 8.708000n 8.58702581e-06 8.710000n 8.5172089e-06 8.712000n 8.44795965e-06 8.714000n 8.37927342e-06 8.716000n 8.31114565e-06 8.718000n 8.2435718e-06 8.720000n 8.17654735e-06 8.722000n 8.11006785e-06 8.724000n 8.04412886e-06 8.726000n 7.97872598e-06 8.728000n 7.91385487e-06 8.730000n 7.84951119e-06 8.732000n 7.78569066e-06 8.734000n 7.72238902e-06 8.736000n 7.65960205e-06 8.738000n 7.59732558e-06 8.740000n 7.53555545e-06 8.742000n 7.47428753e-06 8.744000n 7.41351776e-06 8.746000n 7.35324208e-06 8.748000n 7.29345647e-06 8.750000n 7.23415694e-06 8.752000n 7.17533955e-06 8.754000n 7.11700038e-06 8.756000n 7.05913554e-06 8.758000n 7.00174116e-06 8.760000n 6.94481343e-06 8.762000n 6.88834855e-06 8.764000n 6.83234276e-06 8.766000n 6.77679233e-06 8.768000n 6.72169355e-06 8.770000n 6.66704275e-06 8.772000n 6.61283629e-06 8.774000n 6.55907056e-06 8.776000n 6.50574196e-06 8.778000n 6.45284696e-06 8.780000n 6.40038202e-06 8.782000n 6.34834365e-06 8.784000n 6.29672838e-06 8.786000n 6.24553276e-06 8.788000n 6.19475339e-06 8.790000n 6.14438688e-06 8.792000n 6.09442988e-06 8.794000n 6.04487906e-06 8.796000n 5.99573111e-06 8.798000n 5.94698275e-06 8.800000n 5.89863075e-06 8.802000n 5.85067187e-06 8.804000n 5.80310292e-06 8.806000n 5.75592073e-06 8.808000n 5.70912216e-06 8.810000n 5.66270408e-06 8.812000n 5.61666341e-06 8.814000n 5.57099707e-06 8.816000n 5.52570202e-06 8.818000n 5.48077524e-06 8.820000n 5.43621374e-06 8.822000n 5.39201455e-06 8.824000n 5.34817471e-06 8.826000n 5.30469132e-06 8.828000n 5.26156148e-06 8.830000n 5.2187823e-06 8.832000n 5.17635093e-06 8.834000n 5.13426456e-06 8.836000n 5.09252037e-06 8.838000n 5.05111558e-06 8.840000n 5.01004743e-06 8.842000n 4.96931319e-06 8.844000n 4.92891013e-06 8.846000n 4.88883558e-06 8.848000n 4.84908685e-06 8.850000n 4.8096613e-06 8.852000n 4.7705563e-06 8.854000n 4.73176924e-06 8.856000n 4.69329754e-06 8.858000n 4.65513864e-06 8.860000n 4.61728998e-06 8.862000n 4.57974906e-06 8.864000n 4.54251336e-06 8.866000n 4.50558041e-06 8.868000n 4.46894774e-06 8.870000n 4.43261292e-06 8.872000n 4.39657351e-06 8.874000n 4.36082712e-06 8.876000n 4.32537137e-06 8.878000n 4.2902039e-06 8.880000n 4.25532235e-06 8.882000n 4.22072441e-06 8.884000n 4.18640776e-06 8.886000n 4.15237013e-06 8.888000n 4.11860924e-06 8.890000n 4.08512285e-06 8.892000n 4.05190871e-06 8.894000n 4.01896463e-06 8.896000n 3.98628839e-06 8.898000n 3.95387783e-06 8.900000n 3.92173079e-06 8.902000n 3.88984512e-06 8.904000n 3.85821869e-06 8.906000n 3.8268494e-06 8.908000n 3.79573516e-06 8.910000n 3.7648739e-06 8.912000n 3.73426355e-06 8.914000n 3.70390208e-06 8.916000n 3.67378747e-06 8.918000n 3.6439177e-06 8.920000n 3.61429079e-06 8.922000n 3.58490476e-06 8.924000n 3.55575766e-06 8.926000n 3.52684753e-06 8.928000n 3.49817246e-06 8.930000n 3.46973053e-06 8.932000n 3.44151985e-06 8.934000n 3.41353854e-06 8.936000n 3.38578473e-06 8.938000n 3.35825657e-06 8.940000n 3.33095223e-06 8.942000n 3.30386989e-06 8.944000n 3.27700774e-06 8.946000n 3.250364e-06 8.948000n 3.22393688e-06 8.950000n 3.19772463e-06 8.952000n 3.17172549e-06 8.954000n 3.14593775e-06 8.956000n 3.12035967e-06 8.958000n 3.09498955e-06 8.960000n 3.06982571e-06 8.962000n 3.04486646e-06 8.964000n 3.02011014e-06 8.966000n 2.9955551e-06 8.968000n 2.97119971e-06 8.970000n 2.94704234e-06 8.972000n 2.92308138e-06 8.974000n 2.89931524e-06 8.976000n 2.87574232e-06 8.978000n 2.85236107e-06 8.980000n 2.82916992e-06 8.982000n 2.80616732e-06 8.984000n 2.78335175e-06 8.986000n 2.76072168e-06 8.988000n 2.7382756e-06 8.990000n 2.71601203e-06 8.992000n 2.69392946e-06 8.994000n 2.67202644e-06 8.996000n 2.6503015e-06 8.998000n 2.6287532e-06 9.000000n 2.60738009e-06 9.002000n 2.58618076e-06 9.004000n 2.56515379e-06 9.006000n 2.54429778e-06 9.008000n 2.52361134e-06 9.010000n 2.50309309e-06 9.012000n 2.48274167e-06 9.014000n 2.46255571e-06 9.016000n 2.44253388e-06 9.018000n 2.42267483e-06 9.020000n 2.40297725e-06 9.022000n 2.38343982e-06 9.024000n 2.36406123e-06 9.026000n 2.34484021e-06 9.028000n 2.32577546e-06 9.030000n 2.30686572e-06 9.032000n 2.28810973e-06 9.034000n 2.26950623e-06 9.036000n 2.25105398e-06 9.038000n 2.23275176e-06 9.040000n 2.21459835e-06 9.042000n 2.19659254e-06 9.044000n 2.17873312e-06 9.046000n 2.16101891e-06 9.048000n 2.14344872e-06 9.050000n 2.12602139e-06 9.052000n 2.10873575e-06 9.054000n 2.09159065e-06 9.056000n 2.07458495e-06 9.058000n 0.00281290877 9.060000n 0.0101370117 9.062000n 0.0174073209 9.064000n 0.0246242313 9.066000n 0.0317881353 9.068000n 0.0388994221 9.070000n 0.0459584781 9.072000n 0.0529656871 9.074000n 0.0599214298 9.076000n 0.0668260842 9.078000n 0.0736800255 9.080000n 0.0804836263 9.082000n 0.0872372562 9.084000n 0.0939412823 9.086000n 0.100596069 9.088000n 0.107201978 9.090000n 0.113759368 9.092000n 0.120268595 9.094000n 0.126730014 9.096000n 0.133143975 9.098000n 0.139510827 9.100000n 0.145830916 9.102000n 0.152104586 9.104000n 0.158332177 9.106000n 0.164514028 9.108000n 0.170650474 9.110000n 0.17674185 9.112000n 0.182788486 9.114000n 0.188790711 9.116000n 0.194748851 9.118000n 0.20066323 9.120000n 0.206534169 9.122000n 0.212361988 9.124000n 0.218147002 9.126000n 0.223889528 9.128000n 0.229589875 9.130000n 0.235248355 9.132000n 0.240865275 9.134000n 0.246440939 9.136000n 0.251975652 9.138000n 0.257469714 9.140000n 0.262923423 9.142000n 0.268337076 9.144000n 0.273710966 9.146000n 0.279045387 9.148000n 0.284340628 9.150000n 0.289596977 9.152000n 0.294814719 9.154000n 0.299994138 9.156000n 0.305135515 9.158000n 0.31023913 9.160000n 0.31530526 9.162000n 0.320334181 9.164000n 0.325326165 9.166000n 0.330281485 9.168000n 0.335200408 9.170000n 0.340083204 9.172000n 0.344930136 9.174000n 0.349741469 9.176000n 0.354517464 9.178000n 0.359258381 9.180000n 0.363964476 9.182000n 0.368636006 9.184000n 0.373273225 9.186000n 0.377876385 9.188000n 0.382445735 9.190000n 0.386981525 9.192000n 0.391484001 9.194000n 0.395953407 9.196000n 0.400389986 9.198000n 0.404793979 9.200000n 0.409165626 9.202000n 0.413505165 9.204000n 0.417812831 9.206000n 0.422088857 9.208000n 0.426333478 9.210000n 0.430546923 9.212000n 0.43472942 9.214000n 0.438881199 9.216000n 0.443002484 9.218000n 0.447093498 9.220000n 0.451154466 9.222000n 0.455185606 9.224000n 0.459187139 9.226000n 0.463159281 9.228000n 0.467102249 9.230000n 0.471016257 9.232000n 0.474901517 9.234000n 0.478758241 9.236000n 0.482586638 9.238000n 0.486386917 9.240000n 0.490159283 9.242000n 0.493903943 9.244000n 0.497621098 9.246000n 0.501310952 9.248000n 0.504973705 9.250000n 0.508609556 9.252000n 0.512218702 9.254000n 0.51580134 9.256000n 0.519357665 9.258000n 0.522887869 9.260000n 0.526392145 9.262000n 0.529870682 9.264000n 0.533323671 9.266000n 0.536751298 9.268000n 0.54015375 9.270000n 0.543531211 9.272000n 0.546883867 9.274000n 0.550211897 9.276000n 0.553515484 9.278000n 0.556794807 9.280000n 0.560050044 9.282000n 0.563281373 9.284000n 0.566488967 9.286000n 0.569673003 9.288000n 0.572833653 9.290000n 0.575971089 9.292000n 0.579085481 9.294000n 0.582176998 9.296000n 0.585245809 9.298000n 0.58829208 9.300000n 0.591315977 9.302000n 0.594317665 9.304000n 0.597297305 9.306000n 0.600255061 9.308000n 0.603191093 9.310000n 0.606105561 9.312000n 0.608998622 9.314000n 0.611870434 9.316000n 0.614721154 9.318000n 0.617550936 9.320000n 0.620359934 9.322000n 0.6231483 9.324000n 0.625916187 9.326000n 0.628663744 9.328000n 0.63139112 9.330000n 0.634098465 9.332000n 0.636785925 9.334000n 0.639453647 9.336000n 0.642101774 9.338000n 0.644730452 9.340000n 0.647339823 9.342000n 0.649930028 9.344000n 0.652501209 9.346000n 0.655053505 9.348000n 0.657587056 9.350000n 0.660101998 9.352000n 0.662598468 9.354000n 0.665076602 9.356000n 0.667536535 9.358000n 0.669978401 9.360000n 0.672402331 9.362000n 0.674808458 9.364000n 0.677196913 9.366000n 0.679567825 9.368000n 0.681921324 9.370000n 0.684257536 9.372000n 0.68657659 9.374000n 0.688878611 9.376000n 0.691163724 9.378000n 0.693432053 9.380000n 0.695683722 9.382000n 0.697918853 9.384000n 0.700137567 9.386000n 0.702339986 9.388000n 0.704526228 9.390000n 0.706696413 9.392000n 0.708850658 9.394000n 0.710989081 9.396000n 0.713111798 9.398000n 0.715218924 9.400000n 0.717310573 9.402000n 0.71938686 9.404000n 0.721447897 9.406000n 0.723493796 9.408000n 0.725524669 9.410000n 0.727540625 9.412000n 0.729541775 9.414000n 0.731528226 9.416000n 0.733500088 9.418000n 0.735457467 9.420000n 0.737400469 9.422000n 0.7393292 9.424000n 0.741243766 9.426000n 0.743144269 9.428000n 0.745030813 9.430000n 0.746903502 9.432000n 0.748762435 9.434000n 0.750607716 9.436000n 0.752439443 9.438000n 0.754257717 9.440000n 0.756062636 9.442000n 0.757854298 9.444000n 0.759632801 9.446000n 0.761398241 9.448000n 0.763150714 9.450000n 0.764890316 9.452000n 0.766617141 9.454000n 0.768331283 9.456000n 0.770032835 9.458000n 0.771721889 9.460000n 0.773398538 9.462000n 0.775062872 9.464000n 0.776714982 9.466000n 0.778354957 9.468000n 0.779982887 9.470000n 0.781598861 9.472000n 0.783202966 9.474000n 0.784795289 9.476000n 0.786375916 9.478000n 0.787944934 9.480000n 0.789502429 9.482000n 0.791048483 9.484000n 0.792583183 9.486000n 0.79410661 9.488000n 0.795618848 9.490000n 0.79711998 9.492000n 0.798610085 9.494000n 0.800089246 9.496000n 0.801557544 9.498000n 0.803015056 9.500000n 0.804461864 9.502000n 0.805898045 9.504000n 0.807323678 9.506000n 0.80873884 9.508000n 0.810143608 9.510000n 0.811538058 9.512000n 0.812922267 9.514000n 0.814296308 9.516000n 0.815660258 9.518000n 0.81701419 9.520000n 0.818358177 9.522000n 0.819692293 9.524000n 0.821016611 9.526000n 0.822331201 9.528000n 0.823636137 9.530000n 0.824931487 9.532000n 0.826217324 9.534000n 0.827493717 9.536000n 0.828760734 9.538000n 0.830018446 9.540000n 0.831266921 9.542000n 0.832506225 9.544000n 0.833736427 9.546000n 0.834957594 9.548000n 0.836169791 9.550000n 0.837373085 9.552000n 0.838567541 9.554000n 0.839753224 9.556000n 0.840930199 9.558000n 0.842098529 9.560000n 0.843258278 9.562000n 0.844409509 9.564000n 0.845552284 9.566000n 0.846686666 9.568000n 0.847812716 9.570000n 0.848930496 9.572000n 0.850040065 9.574000n 0.851141486 9.576000n 0.852234816 9.578000n 0.853320116 9.580000n 0.854397445 9.582000n 0.855466862 9.584000n 0.856528423 9.586000n 0.857582188 9.588000n 0.858628213 9.590000n 0.859666555 9.592000n 0.860697271 9.594000n 0.861720417 9.596000n 0.862736048 9.598000n 0.863744219 9.600000n 0.864744985 9.602000n 0.865738401 9.604000n 0.866724521 9.606000n 0.867703398 9.608000n 0.868675085 9.610000n 0.869639635 9.612000n 0.870597101 9.614000n 0.871547535 9.616000n 0.872490988 9.618000n 0.873427511 9.620000n 0.874357156 9.622000n 0.875279973 9.624000n 0.876196012 9.626000n 0.877105323 9.628000n 0.878007956 9.630000n 0.878903958 9.632000n 0.87979338 9.634000n 0.880676269 9.636000n 0.881552674 9.638000n 0.882422641 9.640000n 0.883286219 9.642000n 0.884143454 9.644000n 0.884994393 9.646000n 0.885839082 9.648000n 0.886677567 9.650000n 0.887509893 9.652000n 0.888336106 9.654000n 0.889156251 9.656000n 0.889970372 9.658000n 0.890778514 9.660000n 0.89158072 9.662000n 0.892377034 9.664000n 0.893167499 9.666000n 0.893952158 9.668000n 0.894731055 9.670000n 0.89550423 9.672000n 0.896271727 9.674000n 0.897033586 9.676000n 0.89778985 9.678000n 0.89854056 9.680000n 0.899285755 9.682000n 0.900025477 9.684000n 0.900759767 9.686000n 0.901488663 9.688000n 0.902212205 9.690000n 0.902930433 9.692000n 0.903643386 9.694000n 0.904351103 9.696000n 0.905053621 9.698000n 0.90575098 9.700000n 0.906443217 9.702000n 0.907130369 9.704000n 0.907812474 9.706000n 0.90848957 9.708000n 0.909161692 9.710000n 0.909828878 9.712000n 0.910491164 9.714000n 0.911148585 9.716000n 0.911801178 9.718000n 0.912448977 9.720000n 0.913092019 9.722000n 0.913730337 9.724000n 0.914363967 9.726000n 0.914992944 9.728000n 0.9156173 9.730000n 0.916237071 9.732000n 0.91685229 9.734000n 0.91746299 9.736000n 0.918069205 9.738000n 0.918670968 9.740000n 0.91926831 9.742000n 0.919861265 9.744000n 0.920449865 9.746000n 0.921034142 9.748000n 0.921614128 9.750000n 0.922189853 9.752000n 0.92276135 9.754000n 0.92332865 9.756000n 0.923891783 9.758000n 0.92445078 9.760000n 0.925005671 9.762000n 0.925556486 9.764000n 0.926103256 9.766000n 0.92664601 9.768000n 0.927184778 9.770000n 0.927719589 9.772000n 0.928250471 9.774000n 0.928777454 9.776000n 0.929300567 9.778000n 0.929819838 9.780000n 0.930335294 9.782000n 0.930846965 9.784000n 0.931354878 9.786000n 0.93185906 9.788000n 0.932359539 9.790000n 0.932856342 9.792000n 0.933349496 9.794000n 0.933839029 9.796000n 0.934324965 9.798000n 0.934807333 9.800000n 0.935286158 9.802000n 0.935761465 9.804000n 0.936233282 9.806000n 0.936701634 9.808000n 0.937166545 9.810000n 0.937628042 9.812000n 0.938086149 9.814000n 0.938540892 9.816000n 0.938992294 9.818000n 0.939440382 9.820000n 0.939885178 9.822000n 0.940326707 9.824000n 0.940764993 9.826000n 0.94120006 9.828000n 0.941631932 9.830000n 0.942060631 9.832000n 0.942486182 9.834000n 0.942908608 9.836000n 0.94332793 9.838000n 0.943744173 9.840000n 0.944157359 9.842000n 0.94456751 9.844000n 0.944974648 9.846000n 0.945378797 9.848000n 0.945779976 9.850000n 0.94617821 9.852000n 0.946573518 9.854000n 0.946965923 9.856000n 0.947355446 9.858000n 0.947742107 9.860000n 0.948125929 9.862000n 0.948506932 9.864000n 0.948885136 9.866000n 0.949260563 9.868000n 0.949633232 9.870000n 0.950003164 9.872000n 0.950370379 9.874000n 0.950734897 9.876000n 0.951096737 9.878000n 0.95145592 9.880000n 0.951812465 9.882000n 0.952166391 9.884000n 0.952517717 9.886000n 0.952866464 9.888000n 0.953212648 9.890000n 0.95355629 9.892000n 0.953897408 9.894000n 0.954236021 9.896000n 0.954572146 9.898000n 0.954905803 9.900000n 0.95523701 9.902000n 0.955565783 9.904000n 0.955892142 9.906000n 0.956216104 9.908000n 0.956537686 9.910000n 0.956856906 9.912000n 0.957173782 9.914000n 0.957488331 9.916000n 0.957800569 9.918000n 0.958110514 9.920000n 0.958418182 9.922000n 0.958723591 9.924000n 0.959026756 9.926000n 0.959327695 9.928000n 0.959626423 9.930000n 0.959922958 9.932000n 0.960217314 9.934000n 0.960509508 9.936000n 0.960799557 9.938000n 0.961087475 9.940000n 0.961373278 9.942000n 0.961656982 9.944000n 0.961938602 9.946000n 0.962218154 9.948000n 0.962495653 9.950000n 0.962771114 9.952000n 0.963044551 9.954000n 0.96331598 9.956000n 0.963585415 9.958000n 0.963852872 9.960000n 0.964118364 9.962000n 0.964381906 9.964000n 0.964643513 9.966000n 0.964903198 9.968000n 0.965160975 9.970000n 0.96541686 9.972000n 0.965670865 9.974000n 0.965923004 9.976000n 0.966173291 9.978000n 0.966421741 9.980000n 0.966668365 9.982000n 0.966913178 9.984000n 0.967156193 9.986000n 0.967397423 9.988000n 0.967636881 9.990000n 0.96787458 9.992000n 0.968110534 9.994000n 0.968344755 9.996000n 0.968577255 9.998000n 0.968808048 10.000000n 0.969037145 10.002000n 0.96926456 10.004000n 0.969490304 10.006000n 0.969714391 10.008000n 0.969936832 10.010000n 0.970157638 10.012000n 0.970376823 10.014000n 0.970594399 10.016000n 0.970810376 10.018000n 0.971024767 10.020000n 0.971237583 10.022000n 0.971448836 10.024000n 0.971658538 10.026000n 0.971866699 10.028000n 0.972073331 10.030000n 0.972278446 10.032000n 0.972482054 10.034000n 0.972684167 10.036000n 0.972884795 10.038000n 0.97308395 10.040000n 0.973281642 10.042000n 0.973477882 10.044000n 0.973672681 10.046000n 0.973866049 10.048000n 0.974057997 10.050000n 0.974248534 10.052000n 0.974437673 10.054000n 0.974625422 10.056000n 0.974811792 10.058000n 0.974996794 10.060000n 0.975180436 10.062000n 0.97536273 10.064000n 0.975543685 10.066000n 0.975723311 10.068000n 0.975901617 10.070000n 0.976078614 10.072000n 0.976254311 10.074000n 0.976428718 10.076000n 0.976601843 10.078000n 0.976773697 10.080000n 0.976944289 10.082000n 0.977113628 10.084000n 0.977281723 10.086000n 0.977448583 10.088000n 0.977614218 10.090000n 0.977778636 10.092000n 0.977941847 10.094000n 0.978103859 10.096000n 0.978264681 10.098000n 0.978424321 10.100000n 0.97858279 10.102000n 0.978740094 10.104000n 0.978896243 10.106000n 0.979051245 10.108000n 0.979205109 10.110000n 0.979357842 10.112000n 0.979509454 10.114000n 0.979659952 10.116000n 0.979809345 10.118000n 0.979957641 10.120000n 0.980104847 10.122000n 0.980250972 10.124000n 0.980396024 10.126000n 0.980540011 10.128000n 0.98068294 10.130000n 0.980824819 10.132000n 0.980965656 10.134000n 0.981105459 10.136000n 0.981244235 10.138000n 0.981381991 10.140000n 0.981518736 10.142000n 0.981654477 10.144000n 0.98178922 10.146000n 0.981922974 10.148000n 0.982055746 10.150000n 0.982187542 10.152000n 0.98231837 10.154000n 0.982448238 10.156000n 0.982577151 10.158000n 0.982705118 10.160000n 0.982832145 10.162000n 0.982958238 10.164000n 0.983083406 10.166000n 0.983207654 10.168000n 0.98333099 10.170000n 0.98345342 10.172000n 0.983574951 10.174000n 0.983695589 10.176000n 0.983815341 10.178000n 0.983934214 10.180000n 0.984052213 10.182000n 0.984169346 10.184000n 0.984285618 10.186000n 0.984401036 10.188000n 0.984515607 10.190000n 0.984629336 10.192000n 0.98474223 10.194000n 0.984854295 10.196000n 0.984965537 10.198000n 0.985075961 10.200000n 0.985185575 10.202000n 0.985294383 10.204000n 0.985402392 10.206000n 0.985509608 10.208000n 0.985616037 10.210000n 0.985721684 10.212000n 0.985826554 10.214000n 0.985930655 10.216000n 0.986033991 10.218000n 0.986136568 10.220000n 0.986238392 10.222000n 0.986339468 10.224000n 0.986439801 10.226000n 0.986539397 10.228000n 0.986638262 10.230000n 0.986736401 10.232000n 0.986833819 10.234000n 0.986930522 10.236000n 0.987026514 10.238000n 0.987121801 10.240000n 0.987216388 10.242000n 0.987310281 10.244000n 0.987403484 10.246000n 0.987496002 10.248000n 0.987587841 10.250000n 0.987679006 10.252000n 0.9877695 10.254000n 0.98785933 10.256000n 0.987948501 10.258000n 0.988037016 10.260000n 0.988124881 10.262000n 0.988212101 10.264000n 0.988298681 10.266000n 0.988384624 10.268000n 0.988469936 10.270000n 0.988554622 10.272000n 0.988638686 10.274000n 0.988722132 10.276000n 0.988804965 10.278000n 0.98888719 10.280000n 0.988968811 10.282000n 0.989049832 10.284000n 0.989130259 10.286000n 0.989210094 10.288000n 0.989289344 10.290000n 0.989368011 10.292000n 0.9894461 10.294000n 0.989523616 10.296000n 0.989600563 10.298000n 0.989676944 10.300000n 0.989752765 10.302000n 0.989828028 10.304000n 0.989902739 10.306000n 0.989976901 10.308000n 0.990050518 10.310000n 0.990123595 10.312000n 0.990196135 10.314000n 0.990268142 10.316000n 0.99033962 10.318000n 0.990410573 10.320000n 0.990481005 10.322000n 0.99055092 10.324000n 0.990620321 10.326000n 0.990689213 10.328000n 0.990757598 10.330000n 0.990825481 10.332000n 0.990892866 10.334000n 0.990959756 10.336000n 0.991026154 10.338000n 0.991092065 10.340000n 0.991157492 10.342000n 0.991222438 10.344000n 0.991286907 10.346000n 0.991350903 10.348000n 0.991414428 10.350000n 0.991477487 10.352000n 0.991540083 10.354000n 0.991602219 10.356000n 0.991663899 10.358000n 0.991725125 10.360000n 0.991785902 10.362000n 0.991846233 10.364000n 0.99190612 10.366000n 0.991965568 10.368000n 0.992024579 10.370000n 0.992083157 10.372000n 0.992141304 10.374000n 0.992199024 10.376000n 0.992256321 10.378000n 0.992313196 10.380000n 0.992369654 10.382000n 0.992425697 10.384000n 0.992481328 10.386000n 0.992536551 10.388000n 0.992591369 10.390000n 0.992645783 10.392000n 0.992699798 10.394000n 0.992753416 10.396000n 0.992806641 10.398000n 0.992859474 10.400000n 0.99291192 10.402000n 0.99296398 10.404000n 0.993015658 10.406000n 0.993066956 10.408000n 0.993117878 10.410000n 0.993168425 10.412000n 0.993218602 10.414000n 0.99326841 10.416000n 0.993317851 10.418000n 0.99336693 10.420000n 0.993415649 10.422000n 0.993464009 10.424000n 0.993512014 10.426000n 0.993559667 10.428000n 0.99360697 10.430000n 0.993653925 10.432000n 0.993700536 10.434000n 0.993746804 10.436000n 0.993792732 10.438000n 0.993838323 10.440000n 0.993883579 10.442000n 0.993928502 10.444000n 0.993973096 10.446000n 0.994017362 10.448000n 0.994061303 10.450000n 0.994104922 10.452000n 0.99414822 10.454000n 0.9941912 10.456000n 0.994233864 10.458000n 0.994276215 10.460000n 0.994318255 10.462000n 0.994359986 10.464000n 0.99440141 10.466000n 0.994442531 10.468000n 0.994483349 10.470000n 0.994523867 10.472000n 0.994564088 10.474000n 0.994604014 10.476000n 0.994643646 10.478000n 0.994682987 10.480000n 0.994722039 10.482000n 0.994760805 10.484000n 0.994799285 10.486000n 0.994837483 10.488000n 0.994875401 10.490000n 0.99491304 10.492000n 0.994950402 10.494000n 0.99498749 10.496000n 0.995024306 10.498000n 0.995060851 10.500000n 0.995097128 10.502000n 0.995133139 10.504000n 0.995168885 10.506000n 0.995204368 10.508000n 0.995239591 10.510000n 0.995274555 10.512000n 0.995309262 10.514000n 0.995343715 10.516000n 0.995377914 10.518000n 0.995411862 10.520000n 0.995445561 10.522000n 0.995479012 10.524000n 0.995512218 10.526000n 0.995545179 10.528000n 0.995577899 10.530000n 0.995610378 10.532000n 0.995642619 10.534000n 0.995674623 10.536000n 0.995706392 10.538000n 0.995737927 10.540000n 0.995769231 10.542000n 0.995800305 10.544000n 0.995831151 10.546000n 0.99586177 10.548000n 0.995892165 10.550000n 0.995922336 10.552000n 0.995952285 10.554000n 0.995982015 10.556000n 0.996011526 10.558000n 0.99604082 10.560000n 0.996069899 10.562000n 0.996098765 10.564000n 0.996127419 10.566000n 0.996155862 10.568000n 0.996184096 10.570000n 0.996212123 10.572000n 0.996239944 10.574000n 0.996267561 10.576000n 0.996294975 10.578000n 0.996322187 10.580000n 0.9963492 10.582000n 0.996376014 10.584000n 0.996402632 10.586000n 0.996429053 10.588000n 0.996455281 10.590000n 0.996481316 10.592000n 0.99650716 10.594000n 0.996532814 10.596000n 0.99655828 10.598000n 0.996583558 10.600000n 0.996608651 10.602000n 0.99663356 10.604000n 0.996658286 10.606000n 0.99668283 10.608000n 0.996707194 10.610000n 0.996731379 10.612000n 0.996755386 10.614000n 0.996779217 10.616000n 0.996802873 10.618000n 0.996826355 10.620000n 0.996849664 10.622000n 0.996872803 10.624000n 0.996895771 10.626000n 0.996918571 10.628000n 0.996941204 10.630000n 0.99696367 10.632000n 0.996985971 10.634000n 0.997008108 10.636000n 0.997030083 10.638000n 0.997051896 10.640000n 0.997073549 10.642000n 0.997095044 10.644000n 0.99711638 10.646000n 0.997137559 10.648000n 0.997158583 10.650000n 0.997179453 10.652000n 0.997200169 10.654000n 0.997220733 10.656000n 0.997241146 10.658000n 0.997261409 10.660000n 0.997281524 10.662000n 0.99730149 10.664000n 0.99732131 10.666000n 0.997340984 10.668000n 0.997360514 10.670000n 0.997379901 10.672000n 0.997399145 10.674000n 0.997418247 10.676000n 0.99743721 10.678000n 0.997456033 10.680000n 0.997474718 10.682000n 0.997493265 10.684000n 0.997511677 10.686000n 0.997529953 10.688000n 0.997548095 10.690000n 0.997566103 10.692000n 0.99758398 10.694000n 0.997601725 10.696000n 0.99761934 10.698000n 0.997636825 10.700000n 0.997654182 10.702000n 0.997671411 10.704000n 0.997688514 10.706000n 0.997705492 10.708000n 0.997722344 10.710000n 0.997739073 10.712000n 0.997755679 10.714000n 0.997772163 10.716000n 0.997788526 10.718000n 0.997804769 10.720000n 0.997820892 10.722000n 0.997836897 10.724000n 0.997852785 10.726000n 0.997868555 10.728000n 0.99788421 10.730000n 0.99789975 10.732000n 0.997915176 10.734000n 0.997930489 10.736000n 0.997945689 10.738000n 0.997960777 10.740000n 0.997975755 10.742000n 0.997990622 10.744000n 0.998005381 10.746000n 0.998020031 10.748000n 0.998034573 10.750000n 0.998049009 10.752000n 0.998063338 10.754000n 0.998077563 10.756000n 0.998091683 10.758000n 0.998105699 10.760000n 0.998119612 10.762000n 0.998133423 10.764000n 0.998147133 10.766000n 0.998160741 10.768000n 0.99817425 10.770000n 0.99818766 10.772000n 0.998200971 10.774000n 0.998214185 10.776000n 0.998227301 10.778000n 0.998240321 10.780000n 0.998253246 10.782000n 0.998266075 10.784000n 0.99827881 10.786000n 0.998291452 10.788000n 0.998304001 10.790000n 0.998316458 10.792000n 0.998328823 10.794000n 0.998341097 10.796000n 0.998353281 10.798000n 0.998365376 10.800000n 0.998377382 10.802000n 0.9983893 10.804000n 0.99840113 10.806000n 0.998412873 10.808000n 0.998424531 10.810000n 0.998436102 10.812000n 0.998447588 10.814000n 0.998458991 10.816000n 0.998470309 10.818000n 0.998481544 10.820000n 0.998492697 10.822000n 0.998503768 10.824000n 0.998514757 10.826000n 0.998525666 10.828000n 0.998536494 10.830000n 0.998547244 10.832000n 0.998557914 10.834000n 0.998568505 10.836000n 0.998579019 10.838000n 0.998589456 10.840000n 0.998599816 10.842000n 0.9986101 10.844000n 0.998620309 10.846000n 0.998630442 10.848000n 0.998640501 10.850000n 0.998650487 10.852000n 0.998660398 10.854000n 0.998670238 10.856000n 0.998680004 10.858000n 0.998689699 10.860000n 0.998699323 10.862000n 0.998708876 10.864000n 0.998718359 10.866000n 0.998727773 10.868000n 0.998737117 10.870000n 0.998746393 10.872000n 0.9987556 10.874000n 0.99876474 10.876000n 0.998773812 10.878000n 0.998782819 10.880000n 0.998791758 10.882000n 0.998800633 10.884000n 0.998809442 10.886000n 0.998818186 10.888000n 0.998826866 10.890000n 0.998835483 10.892000n 0.998844036 10.894000n 0.998852526 10.896000n 0.998860954 10.898000n 0.99886932 10.900000n 0.998877625 10.902000n 0.998885868 10.904000n 0.998894051 10.906000n 0.998902174 10.908000n 0.998910237 10.910000n 0.998918241 10.912000n 0.998926187 10.914000n 0.998934074 10.916000n 0.998941903 10.918000n 0.998949674 10.920000n 0.998957388 10.922000n 0.998965046 10.924000n 0.998972648 10.926000n 0.998980193 10.928000n 0.998987684 10.930000n 0.998995119 10.932000n 0.999002499 10.934000n 0.999009826 10.936000n 0.999017098 10.938000n 0.999024318 10.940000n 0.999031484 10.942000n 0.999038597 10.944000n 0.999045659 10.946000n 0.999052668 10.948000n 0.999059626 10.950000n 0.999066533 10.952000n 0.999073389 10.954000n 0.999080195 10.956000n 0.99908695 10.958000n 0.999093656 10.960000n 0.999100313 10.962000n 0.999106921 10.964000n 0.999113481 10.966000n 0.999119992 10.968000n 0.999126455 10.970000n 0.999132871 10.972000n 0.99913924 10.974000n 0.999145562 10.976000n 0.999151838 10.978000n 0.999158068 10.980000n 0.999164251 10.982000n 0.99917039 10.984000n 0.999176483 10.986000n 0.999182532 10.988000n 0.999188536 10.990000n 0.999194496 10.992000n 0.999200412 10.994000n 0.999206285 10.996000n 0.999212114 10.998000n 0.999217901 11.000000n 0.999223646 11.002000n 0.999229348 11.004000n 0.999235008 11.006000n 0.999240627 11.008000n 0.999246204 11.010000n 0.99925174 11.012000n 0.999257236 11.014000n 0.999262692 11.016000n 0.999268107 11.018000n 0.999273483 11.020000n 0.999278819 11.022000n 0.999284116 11.024000n 0.999289374 11.026000n 0.999294593 11.028000n 0.999299774 11.030000n 0.999304917 11.032000n 0.999310022 11.034000n 0.99931509 11.036000n 0.999320121 11.038000n 0.999325114 11.040000n 0.999330071 11.042000n 0.999334991 11.044000n 0.999339876 11.046000n 0.999344724 11.048000n 0.999349537 11.050000n 0.999354315 11.052000n 0.999359057 11.054000n 0.999363765 11.056000n 0.999368438 11.058000n 0.999373076 11.060000n 0.999377681 11.062000n 0.999382252 11.064000n 0.999386789 11.066000n 0.999391293 11.068000n 0.999395764 11.070000n 0.999400201 11.072000n 0.999404607 11.074000n 0.99940898 11.076000n 0.999413321 11.078000n 0.99941763 11.080000n 0.999421907 11.082000n 0.999426153 11.084000n 0.999430368 11.086000n 0.999434552 11.088000n 0.999438705 11.090000n 0.999442827 11.092000n 0.99944692 11.094000n 0.999450982 11.096000n 0.999455014 11.098000n 0.999459017 11.100000n 0.999462991 11.102000n 0.999466935 11.104000n 0.99947085 11.106000n 0.999474736 11.108000n 0.999478594 11.110000n 0.999482424 11.112000n 0.999486225 11.114000n 0.999489999 11.116000n 0.999493745 11.118000n 0.999497463 11.120000n 0.999501154 11.122000n 0.999504818 11.124000n 0.999508455 11.126000n 0.999512065 11.128000n 0.999515649 11.130000n 0.999519207 11.132000n 0.999522738 11.134000n 0.999526243 11.136000n 0.999529723 11.138000n 0.999533177 11.140000n 0.999536606 11.142000n 0.999540009 11.144000n 0.999543388 11.146000n 0.999546741 11.148000n 0.99955007 11.150000n 0.999553375 11.152000n 0.999556655 11.154000n 0.999559912 11.156000n 0.999563144 11.158000n 0.999566353 11.160000n 0.999569538 11.162000n 0.999572699 11.164000n 0.999575838 11.166000n 0.999578953 11.168000n 0.999582046 11.170000n 0.999585115 11.172000n 0.999588163 11.174000n 0.999591187 11.176000n 0.99959419 11.178000n 0.999597171 11.180000n 0.999600129 11.182000n 0.999603066 11.184000n 0.999605982 11.186000n 0.999608876 11.188000n 0.999611748 11.190000n 0.9996146 11.192000n 0.999617431 11.194000n 0.999620241 11.196000n 0.99962303 11.198000n 0.999625799 11.200000n 0.999628547 11.202000n 0.999631275 11.204000n 0.999633983 11.206000n 0.999636672 11.208000n 0.99963934 11.210000n 0.999641989 11.212000n 0.999644619 11.214000n 0.999647229 11.216000n 0.99964982 11.218000n 0.999652392 11.220000n 0.999654945 11.222000n 0.999657479 11.224000n 0.999659995 11.226000n 0.999662492 11.228000n 0.999664971 11.230000n 0.999667432 11.232000n 0.999669875 11.234000n 0.999672299 11.236000n 0.999674706 11.238000n 0.999677095 11.240000n 0.999679467 11.242000n 0.999681821 11.244000n 0.999684158 11.246000n 0.999686478 11.248000n 0.999688781 11.250000n 0.999691067 11.252000n 0.999693336 11.254000n 0.999695588 11.256000n 0.999697824 11.258000n 0.999700043 11.260000n 0.999702246 11.262000n 0.999704433 11.264000n 0.999706604 11.266000n 0.999708759 11.268000n 0.999710898 11.270000n 0.999713022 11.272000n 0.999715129 11.274000n 0.999717222 11.276000n 0.999719299 11.278000n 0.99972136 11.280000n 0.999723407 11.282000n 0.999725438 11.284000n 0.999727455 11.286000n 0.999729457 11.288000n 0.999731444 11.290000n 0.999733416 11.292000n 0.999735374 11.294000n 0.999737318 11.296000n 0.999739247 11.298000n 0.999741162 11.300000n 0.999743064 11.302000n 0.999744951 11.304000n 0.999746824 11.306000n 0.999748683 11.308000n 0.999750529 11.310000n 0.999752362 11.312000n 0.99975418 11.314000n 0.999755986 11.316000n 0.999757778 11.318000n 0.999759557 11.320000n 0.999761323 11.322000n 0.999763076 11.324000n 0.999764816 11.326000n 0.999766544 11.328000n 0.999768258 11.330000n 0.999769961 11.332000n 0.99977165 11.334000n 0.999773327 11.336000n 0.999774992 11.338000n 0.999776645 11.340000n 0.999778285 11.342000n 0.999779914 11.344000n 0.99978153 11.346000n 0.999783135 11.348000n 0.999784728 11.350000n 0.999786309 11.352000n 0.999787878 11.354000n 0.999789436 11.356000n 0.999790983 11.358000n 0.999792518 11.360000n 0.999794042 11.362000n 0.999795555 11.364000n 0.999797056 11.366000n 0.999798547 11.368000n 0.999800026 11.370000n 0.999801495 11.372000n 0.999802953 11.374000n 0.9998044 11.376000n 0.999805837 11.378000n 0.999807263 11.380000n 0.999808679 11.382000n 0.999810084 11.384000n 0.999811479 11.386000n 0.999812863 11.388000n 0.999814238 11.390000n 0.999815602 11.392000n 0.999816957 11.394000n 0.999818301 11.396000n 0.999819636 11.398000n 0.99982096 11.400000n 0.999822275 11.402000n 0.999823581 11.404000n 0.999824876 11.406000n 0.999826163 11.408000n 0.999827439 11.410000n 0.999828707 11.412000n 0.999829965 11.414000n 0.999831214 11.416000n 0.999832454 11.418000n 0.999833684 11.420000n 0.999834906 11.422000n 0.999836118 11.424000n 0.999837322 11.426000n 0.999838517 11.428000n 0.999839703 11.430000n 0.99984088 11.432000n 0.999842049 11.434000n 0.999843209 11.436000n 0.999844361 11.438000n 0.999845504 11.440000n 0.999846638 11.442000n 0.999847765 11.444000n 0.999848883 11.446000n 0.999849993 11.448000n 0.999851095 11.450000n 0.999852188 11.452000n 0.999853274 11.454000n 0.999854352 11.456000n 0.999855421 11.458000n 0.999856483 11.460000n 0.999857537 11.462000n 0.999858584 11.464000n 0.999859622 11.466000n 0.999860653 11.468000n 0.999861677 11.470000n 0.999862693 11.472000n 0.999863701 11.474000n 0.999864702 11.476000n 0.999865696 11.478000n 0.999866683 11.480000n 0.999867662 11.482000n 0.999868634 11.484000n 0.999869599 11.486000n 0.999870556 11.488000n 0.999871507 11.490000n 0.999872451 11.492000n 0.999873388 11.494000n 0.999874318 11.496000n 0.999875241 11.498000n 0.999876157 11.500000n 0.999877067 11.502000n 0.99987797 11.504000n 0.999878866 11.506000n 0.999879756 11.508000n 0.999880639 11.510000n 0.999881515 11.512000n 0.999882386 11.514000n 0.99988325 11.516000n 0.999884107 11.518000n 0.999884958 11.520000n 0.999885803 11.522000n 0.999886642 11.524000n 0.999887475 11.526000n 0.999888301 11.528000n 0.999889121 11.530000n 0.999889936 11.532000n 0.999890744 11.534000n 0.999891547 11.536000n 0.999892343 11.538000n 0.999893134 11.540000n 0.999893919 11.542000n 0.999894698 11.544000n 0.999895471 11.546000n 0.999896239 11.548000n 0.999897001 11.550000n 0.999897758 11.552000n 0.999898509 11.554000n 0.999899254 11.556000n 0.999899994 11.558000n 0.999900729 11.560000n 0.999901458 11.562000n 0.999902181 11.564000n 0.9999029 11.566000n 0.999903613 11.568000n 0.999904321 11.570000n 0.999905024 11.572000n 0.999905721 11.574000n 0.999906414 11.576000n 0.999907101 11.578000n 0.999907783 11.580000n 0.999908461 11.582000n 0.999909133 11.584000n 0.999909801 11.586000n 0.999910463 11.588000n 0.999911121 11.590000n 0.999911773 11.592000n 0.999912421 11.594000n 0.999913065 11.596000n 0.999913703 11.598000n 0.999914337 11.600000n 0.999914966 11.602000n 0.999915591 11.604000n 0.999916211 11.606000n 0.999916826 11.608000n 0.999917437 11.610000n 0.999918043 11.612000n 0.999918645 11.614000n 0.999919243 11.616000n 0.999919836 11.618000n 0.999920425 11.620000n 0.999921009 11.622000n 0.999921589 11.624000n 0.999922165 11.626000n 0.999922737 11.628000n 0.999923305 11.630000n 0.999923868 11.632000n 0.999924427 11.634000n 0.999924982 11.636000n 0.999925533 11.638000n 0.99992608 11.640000n 0.999926623 11.642000n 0.999927162 11.644000n 0.999927697 11.646000n 0.999928228 11.648000n 0.999928755 11.650000n 0.999929278 11.652000n 0.999929798 11.654000n 0.999930313 11.656000n 0.999930825 11.658000n 0.999931333 11.660000n 0.999931838 11.662000n 0.999932338 11.664000n 0.999932835 11.666000n 0.999933329 11.668000n 0.999933818 11.670000n 0.999934304 11.672000n 0.999934787 11.674000n 0.999935266 11.676000n 0.999935741 11.678000n 0.999936213 11.680000n 0.999936682 11.682000n 0.999937147 11.684000n 0.999937608 11.686000n 0.999938067 11.688000n 0.999938522 11.690000n 0.999938973 11.692000n 0.999939421 11.694000n 0.999939866 11.696000n 0.999940308 11.698000n 0.999940746 11.700000n 0.999941182 11.702000n 0.999941614 11.704000n 0.999942042 11.706000n 0.999942468 11.708000n 0.999942891 11.710000n 0.99994331 11.712000n 0.999943726 11.714000n 0.99994414 11.716000n 0.99994455 11.718000n 0.999944957 11.720000n 0.999945362 11.722000n 0.999945763 11.724000n 0.999946161 11.726000n 0.999946557 11.728000n 0.999946949 11.730000n 0.999947339 11.732000n 0.999947726 11.734000n 0.99994811 11.736000n 0.999948491 11.738000n 0.999948869 11.740000n 0.999949245 11.742000n 0.999949617 11.744000n 0.999949987 11.746000n 0.999950355 11.748000n 0.999950719 11.750000n 0.999951081 11.752000n 0.999951441 11.754000n 0.999951797 11.756000n 0.999952151 11.758000n 0.999952503 11.760000n 0.999952852 11.762000n 0.999953198 11.764000n 0.999953542 11.766000n 0.999953883 11.768000n 0.999954222 11.770000n 0.999954558 11.772000n 0.999954892 11.774000n 0.999955223 11.776000n 0.999955552 11.778000n 0.999955878 11.780000n 0.999956202 11.782000n 0.999956524 11.784000n 0.999956843 11.786000n 0.99995716 11.788000n 0.999957475 11.790000n 0.999957787 11.792000n 0.999958097 11.794000n 0.999958405 11.796000n 0.999958711 11.798000n 0.999959014 11.800000n 0.999959315 11.802000n 0.999959614 11.804000n 0.99995991 11.806000n 0.999960205 11.808000n 0.999960497 11.810000n 0.999960787 11.812000n 0.999961075 11.814000n 0.999961361 11.816000n 0.999961645 11.818000n 0.999961927 11.820000n 0.999962206 11.822000n 0.999962484 11.824000n 0.999962759 11.826000n 0.999963033 11.828000n 0.999963304 11.830000n 0.999963574 11.832000n 0.999963842 11.834000n 0.999964107 11.836000n 0.999964371 11.838000n 0.999964632 11.840000n 0.999964892 11.842000n 0.99996515 11.844000n 0.999965406 11.846000n 0.99996566 11.848000n 0.999965912 11.850000n 0.999966163 11.852000n 0.999966411 11.854000n 0.999966658 11.856000n 0.999966903 11.858000n 0.999967146 11.860000n 0.999967387 11.862000n 0.999967627 11.864000n 0.999967864 11.866000n 0.999968101 11.868000n 0.999968335 11.870000n 0.999968567 11.872000n 0.999968798 11.874000n 0.999969027 11.876000n 0.999969255 11.878000n 0.999969481 11.880000n 0.999969705 11.882000n 0.999969927 11.884000n 0.999970148 11.886000n 0.999970368 11.888000n 0.999970585 11.890000n 0.999970801 11.892000n 0.999971016 11.894000n 0.999971229 11.896000n 0.99997144 11.898000n 0.99997165 11.900000n 0.999971858 11.902000n 0.999972065 11.904000n 0.99997227 11.906000n 0.999972473 11.908000n 0.999972676 11.910000n 0.999972876 11.912000n 0.999973075 11.914000n 0.999973273 11.916000n 0.99997347 11.918000n 0.999973664 11.920000n 0.999973858 11.922000n 0.99997405 11.924000n 0.99997424 11.926000n 0.99997443 11.928000n 0.999974617 11.930000n 0.999974804 11.932000n 0.999974989 11.934000n 0.999975173 11.936000n 0.999975355 11.938000n 0.999975536 11.940000n 0.999975716 11.942000n 0.999975894 11.944000n 0.999976071 11.946000n 0.999976247 11.948000n 0.999976421 11.950000n 0.999976594 11.952000n 0.999976766 11.954000n 0.999976937 11.956000n 0.999977106 11.958000n 0.999977275 11.960000n 0.999977441 11.962000n 0.999977607 11.964000n 0.999977772 11.966000n 0.999977935 11.968000n 0.999978097 11.970000n 0.999978258 11.972000n 0.999978418 11.974000n 0.999978576 11.976000n 0.999978733 11.978000n 0.99997889 11.980000n 0.999979045 11.982000n 0.999979199 11.984000n 0.999979351 11.986000n 0.999979503 11.988000n 0.999979654 11.990000n 0.999979803 11.992000n 0.999979951 11.994000n 0.999980099 11.996000n 0.999980245 11.998000n 0.99998039 12.000000n 0.999980534 12.002000n 0.999980677 12.004000n 0.999980819 12.006000n 0.99998096 12.008000n 0.9999811 12.010000n 0.999981238 12.012000n 0.999981376 12.014000n 0.999981513 12.016000n 0.999981649 12.018000n 0.999981783 12.020000n 0.999981917 12.022000n 0.99998205 12.024000n 0.999982182 12.026000n 0.999982313 12.028000n 0.999982443 12.030000n 0.999982572 12.032000n 0.9999827 12.034000n 0.999982827 12.036000n 0.999982953 12.038000n 0.999983078 12.040000n 0.999983202 12.042000n 0.999983326 12.044000n 0.999983448 12.046000n 0.99998357 12.048000n 0.99998369 12.050000n 0.99998381 12.052000n 0.999983929 12.054000n 0.999984047 12.056000n 0.999984164 12.058000n 0.999984281 12.060000n 0.999984396 12.062000n 0.999984511 12.064000n 0.999984625 12.066000n 0.999984737 12.068000n 0.99998485 12.070000n 0.999984961 12.072000n 0.999985071 12.074000n 0.999985181 12.076000n 0.99998529 12.078000n 0.999985398 12.080000n 0.999985505 12.082000n 0.999985612 12.084000n 0.999985717 12.086000n 0.999985822 12.088000n 0.999985926 12.090000n 0.99998603 12.092000n 0.999986132 12.094000n 0.999986234 12.096000n 0.999986335 12.098000n 0.999986436 12.100000n 0.999986535 12.102000n 0.999986634 12.104000n 0.999986732 12.106000n 0.99998683 12.108000n 0.999986926 12.110000n 0.999987022 12.112000n 0.999987118 12.114000n 0.999987212 12.116000n 0.999987306 12.118000n 0.9999874 12.120000n 0.999987492 12.122000n 0.999987584 12.124000n 0.999987675 12.126000n 0.999987766 12.128000n 0.999987856 12.130000n 0.999987945 12.132000n 0.999988033 12.134000n 0.999988121 12.136000n 0.999988208 12.138000n 0.999988295 12.140000n 0.999988381 12.142000n 0.999988466 12.144000n 0.999988551 12.146000n 0.999988635 12.148000n 0.999988719 12.150000n 0.999988801 12.152000n 0.999988884 12.154000n 0.999988965 12.156000n 0.999989046 12.158000n 0.999989127 12.160000n 0.999989207 12.162000n 0.999989286 12.164000n 0.999989365 12.166000n 0.999989443 12.168000n 0.99998952 12.170000n 0.999989597 12.172000n 0.999989674 12.174000n 0.99998975 12.176000n 0.999989825 12.178000n 0.9999899 12.180000n 0.999989974 12.182000n 0.999990047 12.184000n 0.99999012 12.186000n 0.999990193 12.188000n 0.999990265 12.190000n 0.999990337 12.192000n 0.999990408 12.194000n 0.999990478 12.196000n 0.999990548 12.198000n 0.999990617 12.200000n 0.999990686 12.202000n 0.999990755 12.204000n 0.999990823 12.206000n 0.99999089 12.208000n 0.999990957 12.210000n 0.999991023 12.212000n 0.999991089 12.214000n 0.999991155 12.216000n 0.99999122 12.218000n 0.999991284 12.220000n 0.999991348 12.222000n 0.999991412 12.224000n 0.999991475 12.226000n 0.999991537 12.228000n 0.9999916 12.230000n 0.999991661 12.232000n 0.999991723 12.234000n 0.999991783 12.236000n 0.999991844 12.238000n 0.999991904 12.240000n 0.999991963 12.242000n 0.999992022 12.244000n 0.999992081 12.246000n 0.999992139 12.248000n 0.999992197 12.250000n 0.999992254 12.252000n 0.999992311 12.254000n 0.999992367 12.256000n 0.999992423 12.258000n 0.999992479 12.260000n 0.999992534 12.262000n 0.999992589 12.264000n 0.999992643 12.266000n 0.999992698 12.268000n 0.999992751 12.270000n 0.999992804 12.272000n 0.999992857 12.274000n 0.99999291 12.276000n 0.999992962 12.278000n 0.999993013 12.280000n 0.999993065 12.282000n 0.999993116 12.284000n 0.999993166 12.286000n 0.999993216 12.288000n 0.999993266 12.290000n 0.999993316 12.292000n 0.999993365 12.294000n 0.999993414 12.296000n 0.999993462 12.298000n 0.99999351 12.300000n 0.999993558 12.302000n 0.999993605 12.304000n 0.999993652 12.306000n 0.999993699 12.308000n 0.999993745 12.310000n 0.999993791 12.312000n 0.999993836 12.314000n 0.999993882 12.316000n 0.999993927 12.318000n 0.999993971 12.320000n 0.999994015 12.322000n 0.999994059 12.324000n 0.999994103 12.326000n 0.999994146 12.328000n 0.999994189 12.330000n 0.999994232 12.332000n 0.999994274 12.334000n 0.999994316 12.336000n 0.999994358 12.338000n 0.9999944 12.340000n 0.999994441 12.342000n 0.999994482 12.344000n 0.999994522 12.346000n 0.999994562 12.348000n 0.999994602 12.350000n 0.999994642 12.352000n 0.999994681 12.354000n 0.99999472 12.356000n 0.999994759 12.358000n 0.999994798 12.360000n 0.999994836 12.362000n 0.999994874 12.364000n 0.999994911 12.366000n 0.999994949 12.368000n 0.999994986 12.370000n 0.999995023 12.372000n 0.999995059 12.374000n 0.999995096 12.376000n 0.999995132 12.378000n 0.999995167 12.380000n 0.999995203 12.382000n 0.999995238 12.384000n 0.999995273 12.386000n 0.999995308 12.388000n 0.999995342 12.390000n 0.999995376 12.392000n 0.99999541 12.394000n 0.999995444 12.396000n 0.999995478 12.398000n 0.999995511 12.400000n 0.999995544 12.402000n 0.999995577 12.404000n 0.999995609 12.406000n 0.999995641 12.408000n 0.999995673 12.410000n 0.999995705 12.412000n 0.999995737 12.414000n 0.999995768 12.416000n 0.999995799 12.418000n 0.99999583 12.420000n 0.99999586 12.422000n 0.999995891 12.424000n 0.999995921 12.426000n 0.999995951 12.428000n 0.999995981 12.430000n 0.99999601 12.432000n 0.99999604 12.434000n 0.999996069 12.436000n 0.999996098 12.438000n 0.999996126 12.440000n 0.999996155 12.442000n 0.999996183 12.444000n 0.999996211 12.446000n 0.999996239 12.448000n 0.999996266 12.450000n 0.999996294 12.452000n 0.999996321 12.454000n 0.999996348 12.456000n 0.999996375 12.458000n 0.999996402 12.460000n 0.999996428 12.462000n 0.999996454 12.464000n 0.99999648 12.466000n 0.999996506 12.468000n 0.999996532 12.470000n 0.999996557 12.472000n 0.999996582 12.474000n 0.999996608 12.476000n 0.999996633 12.478000n 0.999996657 12.480000n 0.999996682 12.482000n 0.999996706 12.484000n 0.99999673 12.486000n 0.999996754 12.488000n 0.999996778 12.490000n 0.999996802 12.492000n 0.999996825 12.494000n 0.999996849 12.496000n 0.999996872 12.498000n 0.999996895 12.500000n 0.999996918 12.502000n 0.99999694 12.504000n 0.999996963 12.506000n 0.999996985 12.508000n 0.999997007 12.510000n 0.999997029 12.512000n 0.999997051 12.514000n 0.999997073 12.516000n 0.999997094 12.518000n 0.999997115 12.520000n 0.999997137 12.522000n 0.999997158 12.524000n 0.999997179 12.526000n 0.999997199 12.528000n 0.99999722 12.530000n 0.99999724 12.532000n 0.999997261 12.534000n 0.999997281 12.536000n 0.999997301 12.538000n 0.99999732 12.540000n 0.99999734 12.542000n 0.99999736 12.544000n 0.999997379 12.546000n 0.999997398 12.548000n 0.999997417 12.550000n 0.999997436 12.552000n 0.999997455 12.554000n 0.999997474 12.556000n 0.999997492 12.558000n 0.999997511 12.560000n 0.999997529 12.562000n 0.999997547 12.564000n 0.999997565 12.566000n 0.999997583 12.568000n 0.999997601 12.570000n 0.999997619 12.572000n 0.999997636 12.574000n 0.999997653 12.576000n 0.999997671 12.578000n 0.999997688 12.580000n 0.999997705 12.582000n 0.999997722 12.584000n 0.999997738 12.586000n 0.999997755 12.588000n 0.999997771 12.590000n 0.999997788 12.592000n 0.999997804 12.594000n 0.99999782 12.596000n 0.999997836 12.598000n 0.999997852 12.600000n 0.999997868 12.602000n 0.999997884 12.604000n 0.999997899 12.606000n 0.999997915 12.608000n 0.99999793 12.610000n 0.999997945 12.612000n 0.99999796 12.614000n 0.999997975 12.616000n 0.99999799 12.618000n 0.999998005 12.620000n 0.999998019 12.622000n 0.999998034 12.624000n 0.999998048 12.626000n 0.999998063 12.628000n 0.999998077 12.630000n 0.999998091 12.632000n 0.999998105 12.634000n 0.999998119 12.636000n 0.999998133 12.638000n 0.999998147 12.640000n 0.99999816 12.642000n 0.999998174 12.644000n 0.999998187 12.646000n 0.9999982 12.648000n 0.999998214 12.650000n 0.999998227 12.652000n 0.99999824 12.654000n 0.999998253 12.656000n 0.999998266 12.658000n 0.999998278 12.660000n 0.999998291 12.662000n 0.999998303 12.664000n 0.999998316 12.666000n 0.999998328 12.668000n 0.999998341 12.670000n 0.999998353 12.672000n 0.999998365 12.674000n 0.999998377 12.676000n 0.999998389 12.678000n 0.999998401 12.680000n 0.999998412 12.682000n 0.999998424 12.684000n 0.999998436 12.686000n 0.999998447 12.688000n 0.999998459 12.690000n 0.99999847 12.692000n 0.999998481 12.694000n 0.999998492 12.696000n 0.999998503 12.698000n 0.999998514 12.700000n 0.999998525 12.702000n 0.999998536 12.704000n 0.999998547 12.706000n 0.999998557 12.708000n 0.999998568 12.710000n 0.999998579 12.712000n 0.999998589 12.714000n 0.999998599 12.716000n 0.99999861 12.718000n 0.99999862 12.720000n 0.99999863 12.722000n 0.99999864 12.724000n 0.99999865 12.726000n 0.99999866 12.728000n 0.99999867 12.730000n 0.99999868 12.732000n 0.999998689 12.734000n 0.999998699 12.736000n 0.999998708 12.738000n 0.999998718 12.740000n 0.999998727 12.742000n 0.999998737 12.744000n 0.999998746 12.746000n 0.999998755 12.748000n 0.999998764 12.750000n 0.999998773 12.752000n 0.999998782 12.754000n 0.999998791 12.756000n 0.9999988 12.758000n 0.999998809 12.760000n 0.999998818 12.762000n 0.999998826 12.764000n 0.999998835 12.766000n 0.999998844 12.768000n 0.999998852 12.770000n 0.999998861 12.772000n 0.999998869 12.774000n 0.999998877 12.776000n 0.999998886 12.778000n 0.999998894 12.780000n 0.999998902 12.782000n 0.99999891 12.784000n 0.999998918 12.786000n 0.999998926 12.788000n 0.999998934 12.790000n 0.999998942 12.792000n 0.999998949 12.794000n 0.999998957 12.796000n 0.999998965 12.798000n 0.999998972 12.800000n 0.99999898 12.802000n 0.999998987 12.804000n 0.999998995 12.806000n 0.999999002 12.808000n 0.99999901 12.810000n 0.999999017 12.812000n 0.999999024 12.814000n 0.999999031 12.816000n 0.999999038 12.818000n 0.999999045 12.820000n 0.999999052 12.822000n 0.999999059 12.824000n 0.999999066 12.826000n 0.999999073 12.828000n 0.99999908 12.830000n 0.999999087 12.832000n 0.999999093 12.834000n 0.9999991 12.836000n 0.999999107 12.838000n 0.999999113 12.840000n 0.99999912 12.842000n 0.999999126 12.844000n 0.999999133 12.846000n 0.999999139 12.848000n 0.999999145 12.850000n 0.999999152 12.852000n 0.999999158 12.854000n 0.999999164 12.856000n 0.99999917 12.858000n 0.999999176 12.860000n 0.999999182 12.862000n 0.999999188 12.864000n 0.999999194 12.866000n 0.9999992 12.868000n 0.999999206 12.870000n 0.999999212 12.872000n 0.999999218 12.874000n 0.999999223 12.876000n 0.999999229 12.878000n 0.999999235 12.880000n 0.99999924 12.882000n 0.999999246 12.884000n 0.999999252 12.886000n 0.999999257 12.888000n 0.999999262 12.890000n 0.999999268 12.892000n 0.999999273 12.894000n 0.999999279 12.896000n 0.999999284 12.898000n 0.999999289 12.900000n 0.999999294 12.902000n 0.9999993 12.904000n 0.999999305 12.906000n 0.99999931 12.908000n 0.999999315 12.910000n 0.99999932 12.912000n 0.999999325 12.914000n 0.99999933 12.916000n 0.999999335 12.918000n 0.99999934 12.920000n 0.999999345 12.922000n 0.999999349 12.924000n 0.999999354 12.926000n 0.999999359 12.928000n 0.999999364 12.930000n 0.999999368 12.932000n 0.999999373 12.934000n 0.999999377 12.936000n 0.999999382 12.938000n 0.999999387 12.940000n 0.999999391 12.942000n 0.999999396 12.944000n 0.9999994 12.946000n 0.999999404 12.948000n 0.999999409 12.950000n 0.999999413 12.952000n 0.999999417 12.954000n 0.999999422 12.956000n 0.999999426 12.958000n 0.99999943 12.960000n 0.999999434 12.962000n 0.999999439 12.964000n 0.999999443 12.966000n 0.999999447 12.968000n 0.999999451 12.970000n 0.999999455 12.972000n 0.999999459 12.974000n 0.999999463 12.976000n 0.999999467 12.978000n 0.999999471 12.980000n 0.999999475 12.982000n 0.999999478 12.984000n 0.999999482 12.986000n 0.999999486 12.988000n 0.99999949 12.990000n 0.999999494 12.992000n 0.999999497 12.994000n 0.999999501 12.996000n 0.999999505 12.998000n 0.999999508 13.000000n 0.999999512 13.002000n 0.999999515 13.004000n 0.999999519 13.006000n 0.999999523 13.008000n 0.999999526 13.010000n 0.99999953 13.012000n 0.999999533 13.014000n 0.999999536 13.016000n 0.99999954 13.018000n 0.999999543 13.020000n 0.999999547 13.022000n 0.99999955 13.024000n 0.999999553 13.026000n 0.999999557 13.028000n 0.99999956 13.030000n 0.999999563 13.032000n 0.999999566 13.034000n 0.999999569 13.036000n 0.999999573 13.038000n 0.999999576 13.040000n 0.999999579 13.042000n 0.999999582 13.044000n 0.999999585 13.046000n 0.999999588 13.048000n 0.999999591 13.050000n 0.999999594 13.052000n 0.999999597 13.054000n 0.9999996 13.056000n 0.999999603 13.058000n 0.999999606 13.060000n 0.999999609 13.062000n 0.999999612 13.064000n 0.999999614 13.066000n 0.999999617 13.068000n 0.99999962 13.070000n 0.999999623 13.072000n 0.999999626 13.074000n 0.999999628 13.076000n 0.999999631 13.078000n 0.999999634 13.080000n 0.999999637 13.082000n 0.999999639 13.084000n 0.999999642 13.086000n 0.999999645 13.088000n 0.999999647 13.090000n 0.99999965 13.092000n 0.999999652 13.094000n 0.999999655 13.096000n 0.999999657 13.098000n 0.99999966 13.100000n 0.999999662 13.102000n 0.999999665 13.104000n 0.999999667 13.106000n 0.99999967 13.108000n 0.999999672 13.110000n 0.999999675 13.112000n 0.999999677 13.114000n 0.999999679 13.116000n 0.999999682 13.118000n 0.999999684 13.120000n 0.999999686 13.122000n 0.999999689 13.124000n 0.999999691 13.126000n 0.999999693 13.128000n 0.999999695 13.130000n 0.999999698 13.132000n 0.9999997 13.134000n 0.999999702 13.136000n 0.999999704 13.138000n 0.999999707 13.140000n 0.999999709 13.142000n 0.999999711 13.144000n 0.999999713 13.146000n 0.999999715 13.148000n 0.999999717 13.150000n 0.999999719 13.152000n 0.999999721 13.154000n 0.999999723 13.156000n 0.999999725 13.158000n 0.999999727 13.160000n 0.999999729 13.162000n 0.999999731 13.164000n 0.999999733 13.166000n 0.999999735 13.168000n 0.999999737 13.170000n 0.999999739 13.172000n 0.999999741 13.174000n 0.999999743 13.176000n 0.999999745 13.178000n 0.999999747 13.180000n 0.999999749 13.182000n 0.99999975 13.184000n 0.999999752 13.186000n 0.999999754 13.188000n 0.999999756 13.190000n 0.999999758 13.192000n 0.999999759 13.194000n 0.999999761 13.196000n 0.999999763 13.198000n 0.999999765 13.200000n 0.999999766 13.202000n 0.999999768 13.204000n 0.99999977 13.206000n 0.999999772 13.208000n 0.999999773 13.210000n 0.999999775 13.212000n 0.999999777 13.214000n 0.999999778 13.216000n 0.99999978 13.218000n 0.999999781 13.220000n 0.999999783 13.222000n 0.999999785 13.224000n 0.999999786 13.226000n 0.999999788 13.228000n 0.999999789 13.230000n 0.999999791 13.232000n 0.999999792 13.234000n 0.999999794 13.236000n 0.999999795 13.238000n 0.999999797 13.240000n 0.999999798 13.242000n 0.9999998 13.244000n 0.999999801 13.246000n 0.999999803 13.248000n 0.999999804 13.250000n 0.999999806 13.252000n 0.999999807 13.254000n 0.999999809 13.256000n 0.99999981 13.258000n 0.999999811 13.260000n 0.999999813 13.262000n 0.999999814 13.264000n 0.999999816 13.266000n 0.999999817 13.268000n 0.999999818 13.270000n 0.99999982 13.272000n 0.999999821 13.274000n 0.999999822 13.276000n 0.999999824 13.278000n 0.999999825 13.280000n 0.999999826 13.282000n 0.999999827 13.284000n 0.999999829 13.286000n 0.99999983 13.288000n 0.999999831 13.290000n 0.999999832 13.292000n 0.999999834 13.294000n 0.999999835 13.296000n 0.999999836 13.298000n 0.999999837 13.300000n 0.999999838 13.302000n 0.99999984 13.304000n 0.999999841 13.306000n 0.999999842 13.308000n 0.999999843 13.310000n 0.999999844 13.312000n 0.999999845 13.314000n 0.999999847 13.316000n 0.999999848 13.318000n 0.999999849 13.320000n 0.99999985 13.322000n 0.999999851 13.324000n 0.999999852 13.326000n 0.999999853 13.328000n 0.999999854 13.330000n 0.999999855 13.332000n 0.999999856 13.334000n 0.999999857 13.336000n 0.999999859 13.338000n 0.99999986 13.340000n 0.999999861 13.342000n 0.999999862 13.344000n 0.999999863 13.346000n 0.999999864 13.348000n 0.999999865 13.350000n 0.999999866 13.352000n 0.999999867 13.354000n 0.999999868 13.356000n 0.999999869 13.358000n 0.99999987 13.360000n 0.999999871 13.362000n 0.999999871 13.364000n 0.999999872 13.366000n 0.999999873 13.368000n 0.999999874 13.370000n 0.999999875 13.372000n 0.999999876 13.374000n 0.999999877 13.376000n 0.999999878 13.378000n 0.999999879 13.380000n 0.99999988 13.382000n 0.999999881 13.384000n 0.999999881 13.386000n 0.999999882 13.388000n 0.999999883 13.390000n 0.999999884 13.392000n 0.999999885 13.394000n 0.999999886 13.396000n 0.999999887 13.398000n 0.999999887 13.400000n 0.999999888 13.402000n 0.999999889 13.404000n 0.99999989 13.406000n 0.999999891 13.408000n 0.999999892 13.410000n 0.999999892 13.412000n 0.999999893 13.414000n 0.999999894 13.416000n 0.999999895 13.418000n 0.999999895 13.420000n 0.999999896 13.422000n 0.999999897 13.424000n 0.999999898 13.426000n 0.999999898 13.428000n 0.999999899 13.430000n 0.9999999 13.432000n 0.999999901 13.434000n 0.999999901 13.436000n 0.999999902 13.438000n 0.999999903 13.440000n 0.999999904 13.442000n 0.999999904 13.444000n 0.999999905 13.446000n 0.999999906 13.448000n 0.999999906 13.450000n 0.999999907 13.452000n 0.999999908 13.454000n 0.999999908 13.456000n 0.999999909 13.458000n 0.99999991 13.460000n 0.99999991 13.462000n 0.999999911 13.464000n 0.999999912 13.466000n 0.999999912 13.468000n 0.999999913 13.470000n 0.999999914 13.472000n 0.999999914 13.474000n 0.999999915 13.476000n 0.999999916 13.478000n 0.999999916 13.480000n 0.999999917 13.482000n 0.999999917 13.484000n 0.999999918 13.486000n 0.999999919 13.488000n 0.999999919 13.490000n 0.99999992 13.492000n 0.99999992 13.494000n 0.999999921 13.496000n 0.999999922 13.498000n 0.999999922 13.500000n 0.999999923 13.502000n 0.999999923 13.504000n 0.999999924 13.506000n 0.999999924 13.508000n 0.999999925 13.510000n 0.999999926 13.512000n 0.999999926 13.514000n 0.999999927 13.516000n 0.999999927 13.518000n 0.999999928 13.520000n 0.999999928 13.522000n 0.999999929 13.524000n 0.999999929 13.526000n 0.99999993 13.528000n 0.99999993 13.530000n 0.999999931 13.532000n 0.999999931 13.534000n 0.999999932 13.536000n 0.999999932 13.538000n 0.999999933 13.540000n 0.999999933 13.542000n 0.999999934 13.544000n 0.999999934 13.546000n 0.999999935 13.548000n 0.999999935 13.550000n 0.999999936 13.552000n 0.999999936 13.554000n 0.999999937 13.556000n 0.999999937 13.558000n 0.999999938 13.560000n 0.999999938 13.562000n 0.999999939 13.564000n 0.999999939 13.566000n 0.999999939 13.568000n 0.99999994 13.570000n 0.99999994 13.572000n 0.999999941 13.574000n 0.999999941 13.576000n 0.999999942 13.578000n 0.999999942 13.580000n 0.999999942 13.582000n 0.999999943 13.584000n 0.999999943 13.586000n 0.999999944 13.588000n 0.999999944 13.590000n 0.999999945 13.592000n 0.999999945 13.594000n 0.999999945 13.596000n 0.999999946 13.598000n 0.999999946 13.600000n 0.999999947 13.602000n 0.999999947 13.604000n 0.999999947 13.606000n 0.999999948 13.608000n 0.999999948 13.610000n 0.999999948 13.612000n 0.999999949 13.614000n 0.999999949 13.616000n 0.99999995 13.618000n 0.99999995 13.620000n 0.99999995 13.622000n 0.999999951 13.624000n 0.999999951 13.626000n 0.999999951 13.628000n 0.999999952 13.630000n 0.999999952 13.632000n 0.999999952 13.634000n 0.999999953 13.636000n 0.999999953 13.638000n 0.999999954 13.640000n 0.999999954 13.642000n 0.999999954 13.644000n 0.999999955 13.646000n 0.999999955 13.648000n 0.999999955 13.650000n 0.999999956 13.652000n 0.999999956 13.654000n 0.999999956 13.656000n 0.999999957 13.658000n 0.999999957 13.660000n 0.999999957 13.662000n 0.999999957 13.664000n 0.999999958 13.666000n 0.999999958 13.668000n 0.999999958 13.670000n 0.999999959 13.672000n 0.999999959 13.674000n 0.999999959 13.676000n 0.99999996 13.678000n 0.99999996 13.680000n 0.99999996 13.682000n 0.99999996 13.684000n 0.999999961 13.686000n 0.999999961 13.688000n 0.999999961 13.690000n 0.999999962 13.692000n 0.999999962 13.694000n 0.999999962 13.696000n 0.999999962 13.698000n 0.999999963 13.700000n 0.999999963 13.702000n 0.999999963 13.704000n 0.999999964 13.706000n 0.999999964 13.708000n 0.999999964 13.710000n 0.999999964 13.712000n 0.999999965 13.714000n 0.999999965 13.716000n 0.999999965 13.718000n 0.999999965 13.720000n 0.999999966 13.722000n 0.999999966 13.724000n 0.999999966 13.726000n 0.999999966 13.728000n 0.999999967 13.730000n 0.999999967 13.732000n 0.999999967 13.734000n 0.999999967 13.736000n 0.999999968 13.738000n 0.999999968 13.740000n 0.999999968 13.742000n 0.999999968 13.744000n 0.999999969 13.746000n 0.999999969 13.748000n 0.999999969 13.750000n 0.999999969 13.752000n 0.999999969 13.754000n 0.99999997 13.756000n 0.99999997 13.758000n 0.99999997 13.760000n 0.99999997 13.762000n 0.999999971 13.764000n 0.999999971 13.766000n 0.999999971 13.768000n 0.999999971 13.770000n 0.999999971 13.772000n 0.999999972 13.774000n 0.999999972 13.776000n 0.999999972 13.778000n 0.999999972 13.780000n 0.999999972 13.782000n 0.999999973 13.784000n 0.999999973 13.786000n 0.999999973 13.788000n 0.999999973 13.790000n 0.999999973 13.792000n 0.999999974 13.794000n 0.999999974 13.796000n 0.999999974 13.798000n 0.999999974 13.800000n 0.999999974 13.802000n 0.999999975 13.804000n 0.999999975 13.806000n 0.999999975 13.808000n 0.999999975 13.810000n 0.999999975 13.812000n 0.999999976 13.814000n 0.999999976 13.816000n 0.999999976 13.818000n 0.999999976 13.820000n 0.999999976 13.822000n 0.999999976 13.824000n 0.999999977 13.826000n 0.999999977 13.828000n 0.999999977 13.830000n 0.999999977 13.832000n 0.999999977 13.834000n 0.999999977 13.836000n 0.999999978 13.838000n 0.999999978 13.840000n 0.999999978 13.842000n 0.999999978 13.844000n 0.999999978 13.846000n 0.999999978 13.848000n 0.999999979 13.850000n 0.999999979 13.852000n 0.999999979 13.854000n 0.999999979 13.856000n 0.999999979 13.858000n 0.999999979 13.860000n 0.999999979 13.862000n 0.99999998 13.864000n 0.99999998 13.866000n 0.99999998 13.868000n 0.99999998 13.870000n 0.99999998 13.872000n 0.99999998 13.874000n 0.999999981 13.876000n 0.999999981 13.878000n 0.999999981 13.880000n 0.999999981 13.882000n 0.999999981 13.884000n 0.999999981 13.886000n 0.999999981 13.888000n 0.999999982 13.890000n 0.999999982 13.892000n 0.999999982 13.894000n 0.999999982 13.896000n 0.999999982 13.898000n 0.999999982 13.900000n 0.999999982 13.902000n 0.999999982 13.904000n 0.999999983 13.906000n 0.999999983 13.908000n 0.999999983 13.910000n 0.999999983 13.912000n 0.999999983 13.914000n 0.999999983 13.916000n 0.999999983 13.918000n 0.999999983 13.920000n 0.999999984 13.922000n 0.999999984 13.924000n 0.999999984 13.926000n 0.999999984 13.928000n 0.999999984 13.930000n 0.999999984 13.932000n 0.999999984 13.934000n 0.999999984 13.936000n 0.999999985 13.938000n 0.999999985 13.940000n 0.999999985 13.942000n 0.999999985 13.944000n 0.999999985 13.946000n 0.999999985 13.948000n 0.999999985 13.950000n 0.999999985 13.952000n 0.999999985 13.954000n 0.999999986 13.956000n 0.999999986 13.958000n 0.999999986 13.960000n 0.999999986 13.962000n 0.999999986 13.964000n 0.999999986 13.966000n 0.999999986 13.968000n 0.999999986 13.970000n 0.999999986 13.972000n 0.999999986 13.974000n 0.999999987 13.976000n 0.999999987 13.978000n 0.999999987 13.980000n 0.999999987 13.982000n 0.999999987 13.984000n 0.999999987 13.986000n 0.999999987 13.988000n 0.999999987 13.990000n 0.999999987 13.992000n 0.999999987 13.994000n 0.999999987 13.996000n 0.999999988 13.998000n 0.999999988 14.000000n 0.999999988)
BKUONA KUONA 0 V = pwl(min(max(V(GUPA), 0), 1), 0.0, 3.0093921634162756e-06, 0.0125, 0.05228750725535794, 0.025, 0.05473144254378619, 0.037500000000000006, 0.05694942046171046, 0.05, 0.0594729230268018, 0.0625, 0.06191050032241303, 0.07500000000000001, 0.06417867005234057, 0.08750000000000001, 0.06683172310613945, 0.1, 0.06893191714565297, 0.1125, 0.07289923298818231, 0.125, 0.07731203956560528, 0.1375, 0.08043810307856031, 0.15000000000000002, 0.08410618091017324, 0.1625, 0.08643811503597193, 0.17500000000000002, 0.08938852473411917, 0.1875, 0.0937848651286308, 0.2, 0.10623487896441042, 0.21250000000000002, 0.1133418350772213, 0.225, 0.11998834287165722, 0.23750000000000002, 0.1253154981847289, 0.25, 0.1303854409563551, 0.2625, 0.13849525171344862, 0.275, 0.1727016726609013, 0.28750000000000003, 0.1867356948981539, 0.30000000000000004, 0.2037520099670899, 0.3125, 0.2190844856073046, 0.325, 0.2336866364414111, 0.3375, 0.26773641055704833, 0.35000000000000003, 0.2981260578661715, 0.36250000000000004, 0.3243664804008222, 0.375, 0.3495783188150553, 0.3875, 0.3642024126847436, 0.4, 0.3648475476937759, 0.41250000000000003, 0.3821635034580908, 0.42500000000000004, 0.39804672358091986, 0.4375, 0.41515315416854426, 0.45, 0.43435193572389874, 0.4625, 0.44548912403938934, 0.47500000000000003, 0.4614388573206766, 0.48750000000000004, 0.4734714972338381, 0.5, 0.48118513240897204, 0.5125000000000001, 0.49375016762660684, 0.525, 0.5086829426520645, 0.5375, 0.5232351460021714, 0.55, 0.5345357321658584, 0.5625, 0.5477710363618739, 0.5750000000000001, 0.5618937002213381, 0.5875, 0.5765049687385937, 0.6000000000000001, 0.5917548488649643, 0.6125, 0.6051829124154585, 0.625, 0.6201118854553043, 0.6375000000000001, 0.6345202011229166, 0.65, 0.6495763130877753, 0.6625000000000001, 0.6663222794216381, 0.675, 0.6820919312587257, 0.6875, 0.6965680857205023, 0.7000000000000001, 0.7129231353150218, 0.7125, 0.7297114646249641, 0.7250000000000001, 0.7470059314439111, 0.7375, 0.7610331070375654, 0.75, 0.7762805198073346, 0.7625000000000001, 0.7943231518328329, 0.775, 0.8121843277705059, 0.7875000000000001, 0.8215595088484473, 0.8, 0.8371586279051473, 0.8125, 0.8508366287742789, 0.8250000000000001, 0.8676891707453597, 0.8375, 0.8790348976352548, 0.8500000000000001, 0.8907300138393146, 0.8625, 0.9042702710677536, 0.875, 0.916574173653605, 0.8875000000000001, 0.9278777680724882, 0.9, 0.9375792755328698, 0.9125000000000001, 0.9449786416425654, 0.925, 0.9568110791625042, 0.9375, 0.9677404047774579, 0.9500000000000001, 0.9735839547909003, 0.9625, 0.9873260635838413, 0.9750000000000001, 0.9890850427980586, 0.9875, 0.9966945057747306, 1.0, 0.9954751204465254)
BKUOFFA KUOFFA 0 V = pwl(min(max(V(GUPA), 0), 1), 0.0, 3.0093921634162756e-06, 0.0125, -0.0022740802533943055, 0.025, 0.029417165566120222, 0.037500000000000006, 0.041208673921319675, 0.05, 0.04475078297130246, 0.0625, 0.07098024046400916, 0.07500000000000001, 0.07741913867904851, 0.08750000000000001, 0.07874556587711407, 0.1, 0.09731196911044823, 0.1125, 0.12110585930658176, 0.125, 0.14077328207908307, 0.1375, 0.14417823966331292, 0.15000000000000002, 0.14419249382195165, 0.1625, 0.15579989154463436, 0.17500000000000002, 0.17633347745133762, 0.1875, 0.19918972825476444, 0.2, 0.2256193773962982, 0.21250000000000002, 0.2434153507411666, 0.225, 0.2550398210969347, 0.23750000000000002, 0.24884746218272497, 0.25, 0.24991800768539454, 0.2625, 0.2639645415910423, 0.275, 0.276133800935059, 0.28750000000000003, 0.2901351268715241, 0.30000000000000004, 0.30915703180539084, 0.3125, 0.332201666623121, 0.325, 0.34621416695020113, 0.3375, 0.3589676006595363, 0.35000000000000003, 0.3684945269589724, 0.36250000000000004, 0.3661627367798748, 0.375, 0.373699158340551, 0.3875, 0.3867081547890766, 0.4, 0.4009040819255699, 0.41250000000000003, 0.41932414540329604, 0.42500000000000004, 0.44625381060717145, 0.4375, 0.46751017239711473, 0.45, 0.4838832240902737, 0.4625, 0.49578922052631086, 0.47500000000000003, 0.5052318043069666, 0.48750000000000004, 0.5080216178577868, 0.5, 0.5071931985289652, 0.5125000000000001, 0.5152044705693055, 0.525, 0.531875327909723, 0.5375, 0.549669150327503, 0.55, 0.5703369119551978, 0.5625, 0.5910046735828924, 0.5750000000000001, 0.614461308074367, 0.5875, 0.6381130743410517, 0.6000000000000001, 0.6539714841346385, 0.6125, 0.6606583916685312, 0.625, 0.6673452992024239, 0.6375000000000001, 0.6675051225163636, 0.65, 0.6664968576132405, 0.6625000000000001, 0.6665103425594637, 0.675, 0.6764172302084827, 0.6875, 0.6863241178575016, 0.7000000000000001, 0.6993367403104283, 0.7125, 0.7257885770727429, 0.7250000000000001, 0.7522404138350578, 0.7375, 0.7759341074002183, 0.75, 0.779817954105221, 0.7625000000000001, 0.7837018008102237, 0.775, 0.7875856475152263, 0.7875000000000001, 0.7795233095520633, 0.8, 0.7699594175910418, 0.8125, 0.7603955256300203, 0.8250000000000001, 0.7682453081276739, 0.8375, 0.7951997754871764, 0.8500000000000001, 0.8221542428466792, 0.8625, 0.8491087102061816, 0.875, 0.8579263679975605, 0.8875000000000001, 0.864223306289378, 0.9, 0.8705202445811956, 0.9125000000000001, 0.8759421131111564, 0.925, 0.8714935212825247, 0.9375, 0.867044929453893, 0.9500000000000001, 0.8625963376252612, 0.9625, 0.8629967341120316, 0.9750000000000001, 0.922041524008766, 0.9875, 0.9810863139055, 1.0, 0.9954751204465254)
BKUA KUA 0 V = (V(GUPTARGET) >= V(GUPA)) ? V(KUONA) : V(KUOFFA)
BKDONA KDONA 0 V = pwl(min(max(V(GDNA), 0), 1), 0.0, 4.734612809328741e-08, 0.0125, 0.05329236484759367, 0.025, 0.05592169527131164, 0.037500000000000006, 0.05860503093416337, 0.05, 0.06192463935811757, 0.0625, 0.06616776156175838, 0.07500000000000001, 0.07127020676008339, 0.08750000000000001, 0.07664534704163428, 0.1, 0.08159526091120332, 0.1125, 0.09068545347124693, 0.125, 0.10432136181993282, 0.1375, 0.11217859876232435, 0.15000000000000002, 0.1182859980897553, 0.1625, 0.12246727248289223, 0.17500000000000002, 0.12905993884456868, 0.1875, 0.13435731995448283, 0.2, 0.13749442061316336, 0.21250000000000002, 0.1451352774351428, 0.225, 0.1504826730552962, 0.23750000000000002, 0.1551080436124774, 0.25, 0.16268982060625972, 0.2625, 0.18311624575052796, 0.275, 0.19936530913391662, 0.28750000000000003, 0.21030174466734777, 0.30000000000000004, 0.21878783626418608, 0.3125, 0.2274574134824358, 0.325, 0.23628721756434404, 0.3375, 0.2444067787068425, 0.35000000000000003, 0.2533371580638324, 0.36250000000000004, 0.26572143746566984, 0.375, 0.2842671775800465, 0.3875, 0.3091399689527781, 0.4, 0.3203906864815231, 0.41250000000000003, 0.3336544607784517, 0.42500000000000004, 0.3466905933519557, 0.4375, 0.3600060451476511, 0.45, 0.38250177617373204, 0.4625, 0.39963266837509626, 0.47500000000000003, 0.40357968468733874, 0.48750000000000004, 0.4189293882721403, 0.5, 0.4340118617625959, 0.5125000000000001, 0.4493780935085833, 0.525, 0.4681469566705732, 0.5375, 0.48896563115025043, 0.55, 0.5051973559321297, 0.5625, 0.5266300282737097, 0.5750000000000001, 0.545797012892126, 0.5875, 0.5669863776375242, 0.6000000000000001, 0.5883523215028394, 0.6125, 0.6102267343270952, 0.625, 0.6228207368472676, 0.6375000000000001, 0.6416973961388471, 0.65, 0.6676057419657759, 0.6625000000000001, 0.6930517199989947, 0.675, 0.720077011120205, 0.6875, 0.7468837461673431, 0.7000000000000001, 0.7537720936503999, 0.7125, 0.7814580000048994, 0.7250000000000001, 0.8114384435642582, 0.7375, 0.8446200515351998, 0.75, 0.8502914687301576, 0.7625000000000001, 0.8595681290663328, 0.775, 0.8833376517019619, 0.7875000000000001, 0.9089337898629851, 0.8, 0.9301369864272714, 0.8125, 0.9217607180135138, 0.8250000000000001, 0.9362729413727154, 0.8375, 0.9520320809305952, 0.8500000000000001, 0.9531743375214106, 0.8625, 0.9628214532174169, 0.875, 0.9734256255523317, 0.8875000000000001, 0.9749777035023779, 0.9, 0.9804983662074728, 0.9125000000000001, 0.9849537531782325, 0.925, 0.9875221242825095, 0.9375, 0.9925942194348838, 0.9500000000000001, 0.9956033021545923, 0.9625, 0.9963845565173853, 0.9750000000000001, 0.9980287476869627, 0.9875, 0.9996404045718792, 1.0, 1.0008237983799224)
BKDOFFA KDOFFA 0 V = pwl(min(max(V(GDNA), 0), 1), 0.0, 4.734612809328741e-08, 0.0125, 0.014064222783434171, 0.025, 0.014733707008303135, 0.037500000000000006, 0.01677512272559132, 0.05, 0.023204673256761052, 0.0625, 0.028554756800513014, 0.07500000000000001, 0.03814518291689158, 0.08750000000000001, 0.039218698095390365, 0.1, 0.05376346386716841, 0.1125, 0.05564312016995136, 0.125, 0.07171654463865561, 0.1375, 0.07956733246885798, 0.15000000000000002, 0.09046044752102987, 0.1625, 0.10999639745338995, 0.17500000000000002, 0.12803964284848068, 0.1875, 0.1387333192307466, 0.2, 0.1479701252887331, 0.21250000000000002, 0.16441791439868844, 0.225, 0.18019434514432778, 0.23750000000000002, 0.17795796412176285, 0.25, 0.19933092682632264, 0.2625, 0.22040554074558202, 0.275, 0.2393888362497798, 0.28750000000000003, 0.2459954388895755, 0.30000000000000004, 0.26706649658870724, 0.3125, 0.2853568065798054, 0.325, 0.302073068512964, 0.3375, 0.32291825675049185, 0.35000000000000003, 0.34267303215998873, 0.36250000000000004, 0.36069288998617083, 0.375, 0.3798680393506801, 0.3875, 0.3997735650314865, 0.4, 0.4181429394974808, 0.41250000000000003, 0.43633404204578286, 0.42500000000000004, 0.4543308052332155, 0.4375, 0.4722127666433587, 0.45, 0.49330535696798083, 0.4625, 0.5096890496389063, 0.47500000000000003, 0.530030567321489, 0.48750000000000004, 0.547021926501666, 0.5, 0.5630654900586055, 0.5125000000000001, 0.5791156091175842, 0.525, 0.5956807446959247, 0.5375, 0.6093276570863156, 0.55, 0.6385269244213276, 0.5625, 0.6591248931844897, 0.5750000000000001, 0.6746229781737704, 0.5875, 0.6880926247133184, 0.6000000000000001, 0.7003363626197371, 0.6125, 0.7237565394862068, 0.625, 0.7512205757602135, 0.6375000000000001, 0.7669386055815546, 0.65, 0.7765505065694908, 0.6625000000000001, 0.7847129233988287, 0.675, 0.7926150524946639, 0.6875, 0.8005433333475432, 0.7000000000000001, 0.8085735285479029, 0.7125, 0.8167683054576113, 0.7250000000000001, 0.8264709461234827, 0.7375, 0.8381788441066993, 0.75, 0.8578407871752743, 0.7625000000000001, 0.8698051839926956, 0.775, 0.8757725898657829, 0.7875000000000001, 0.8798005793477042, 0.8, 0.8842942269186163, 0.8125, 0.8891936971246026, 0.8250000000000001, 0.8931033121444052, 0.8375, 0.8976641135683293, 0.8500000000000001, 0.9035193281196118, 0.8625, 0.912966815081816, 0.875, 0.923968820041983, 0.8875000000000001, 0.9272938541394216, 0.9, 0.930593018329846, 0.9125000000000001, 0.9338210469884203, 0.925, 0.9362369536268493, 0.9375, 0.9378013356381388, 0.9500000000000001, 0.9401984251963456, 0.9625, 0.9430139937342643, 0.9750000000000001, 0.9457162600349911, 0.9875, 0.9483897962387776, 1.0, 1.0008237983799224)
BKDA KDA 0 V = (V(GDNTARGET) >= V(GDNA)) ? V(KDONA) : V(KDOFFA)
R1A OUTA MIDA {R_pkg}
L1A DIEA MIDA {L_pkg}
C1A OUTA VSS {C_pkg}
C2A DIEA VSS {C_comp}
V1A PWR_CLAMP_REFA VCC 0
B1A DIEA PWR_CLAMP_REFA I = pwl(V(DIEA,VSS), 3.3, 8.061e-10, 3.3333, 1.728e-09, 3.3667, 4.351e-09, 3.4, 1.2400000000000002e-08, 3.4333, 3.6880000000000003e-08, 3.4667, 1.087e-07, 3.5, 3.103e-07, 3.5332999999999997, 8.498999999999999e-07, 3.5667, 2.229e-06, 3.5999999999999996, 5.612e-06, 3.6332999999999998, 1.35e-05, 3.6666999999999996, 3.039e-05, 3.6999999999999997, 6.227e-05, 3.7333, 0.0001146, 3.7666999999999997, 0.0001905, 3.8, 0.00029, 3.8333, 0.00041170000000000003, 3.8667, 0.0005534, 3.9, 0.0007134000000000001, 3.9333, 0.0008901, 3.9667, 0.001083, 4.0, 0.0012900000000000001, 4.0333, 0.001512, 4.0667, 0.001747, 4.1, 0.001997, 4.1333, 0.00226, 4.1667, 0.002536, 4.2, 0.0028239999999999997, 4.2333, 0.003126, 4.2667, 0.00344, 4.3, 0.003767, 4.3332999999999995, 0.004107, 4.3667, 0.004458999999999999, 4.4, 0.004823000000000001, 4.4333, 0.005198, 4.4666999999999994, 0.005586000000000001, 4.5, 0.005986, 4.5333, 0.006397000000000001, 4.5667, 0.0068200000000000005, 4.6, 0.007256, 4.6333, 0.007703000000000001, 4.6667, 0.008162, 4.699999999999999, 0.008633, 4.7333, 0.009115999999999999, 4.7667, 0.009611000000000001, 4.8, 0.010119999999999999, 4.8332999999999995, 0.01064, 4.8667, 0.01117, 4.9, 0.011720000000000001, 4.9333, 0.01228, 4.9666999999999994, 0.01285, 5.0, 0.01343, 5.0333, 0.014029999999999999, 5.0667, 0.01465, 5.1, 0.01527, 5.1333, 0.01592, 5.1667, 0.01657, 5.199999999999999, 0.01725, 5.2333, 0.01793, 5.2667, 0.01864, 5.3, 0.01936, 5.3332999999999995, 0.020100000000000003, 5.3667, 0.02086, 5.4, 0.02163, 5.4333, 0.02243, 5.4666999999999994, 0.02324, 5.5, 0.024079999999999997, 5.5333, 0.02493, 5.5667, 0.02581, 5.6, 0.02671, 5.6333, 0.02764, 5.6667, 0.028579999999999998, 5.699999999999999, 0.02956, 5.7333, 0.03056, 5.7667, 0.03158, 5.8, 0.03264, 5.8332999999999995, 0.03372, 5.8667, 0.03483, 5.9, 0.03598, 5.9333, 0.03716, 5.9666999999999994, 0.03837, 6.0, 0.039619999999999995, 6.0333, 0.040909999999999995, 6.0667, 0.04223, 6.1, 0.0436, 6.1333, 0.045, 6.1667, 0.046450000000000005, 6.199999999999999, 0.047939999999999997, 6.2333, 0.04947, 6.2667, 0.05105, 6.3, 0.05267, 6.3332999999999995, 0.054340000000000006, 6.3667, 0.05604, 6.4, 0.05779, 6.4333, 0.05958, 6.4666999999999994, 0.06141, 6.5, 0.06328, 6.5333, 0.06518, 6.5667, 0.06712, 6.6, 0.0691)
V2A GND_CLAMP_REFA VSS 0
B2A DIEA GND_CLAMP_REFA I = pwl(V(DIEA,VSS), -3.3, -0.034820000000000004, -3.2333, -0.03558, -3.1667, -0.03637, -3.1, -0.03718, -3.0333, -0.038020000000000005, -2.9667, -0.0389, -2.9, -0.039799999999999995, -2.8333, -0.040729999999999995, -2.7667, -0.0417, -2.7, -0.04269, -2.6333, -0.04372, -2.5667, -0.044770000000000004, -2.5, -0.04585, -2.4333, -0.04696, -2.3667, -0.04808, -2.3, -0.049229999999999996, -2.2333, -0.05038, -2.1667, -0.05154, -2.1, -0.05269, -2.0333, -0.053810000000000004, -1.9667, -0.0549, -1.9, -0.05593, -1.8333, -0.05687, -1.7667, -0.0577, -1.7, -0.05838, -1.6333, -0.05886, -1.5667, -0.059090000000000004, -1.5, -0.05892, -1.4333, -0.05745, -1.3667, -0.05546, -1.3, -0.05303, -1.2333, -0.05013, -1.1667, -0.04675, -1.1, -0.04291, -1.0333, -0.03866, -0.9667, -0.03408, -0.9, -0.02929, -0.8333, -0.024440000000000003, -0.7667, -0.01968, -0.7, -0.01518, -0.6333, -0.0111, -0.5667, -0.007562, -0.5, -0.004690000000000001, -0.4333, -0.002529, -0.3667, -0.0010400000000000001, -0.3, -0.00021, -0.2333, -1.2199999999999998e-05, -0.1667, -5.128e-07, -0.1, -2.4280000000000003e-08, -0.033333, -1.662e-09, 0.033333, -1.016e-10, 0.1, -2.448e-11, 0.1667, -1.042e-11, 0.2333, -2.5530000000000003e-13, 0.3, 9.069e-12, 0.3667, 1.812e-11, 0.4333, 2.708e-11, 0.5, 3.601e-11, 0.5667, 4.4950000000000004e-11, 0.6333, 5.392e-11, 0.7, 6.293e-11, 0.7667, 7.198999999999999e-11, 0.8333, 8.11e-11, 0.9, 9.028e-11, 0.9667, 9.952e-11, 1.0333, 1.088e-10, 1.1, 1.1820000000000002e-10, 1.1667, 1.276e-10, 1.2333, 1.371e-10, 1.3, 1.467e-10, 1.3667, 1.563e-10, 1.4333, 1.661e-10, 1.5, 1.759e-10, 1.5667, 1.8570000000000002e-10, 1.6333, 1.9570000000000003e-10, 1.7, 2.057e-10, 1.7667, 2.158e-10, 1.8333, 2.2600000000000002e-10, 1.9, 2.363e-10, 1.9667, 2.466e-10, 2.0333, 2.5700000000000004e-10, 2.1, 2.675e-10, 2.1667, 2.7810000000000005e-10, 2.2333, 2.8880000000000003e-10, 2.3, 2.996e-10, 2.3667, 3.1040000000000003e-10, 2.4333, 3.2140000000000005e-10, 2.5, 3.324e-10, 2.5667, 3.4350000000000005e-10, 2.6333, 3.548e-10, 2.7, 3.661e-10, 2.7667, 3.7750000000000004e-10, 2.8333, 3.8900000000000005e-10, 2.9, 4.007e-10, 2.9667, 4.125e-10, 3.0333, 4.2450000000000003e-10, 3.1, 4.3690000000000006e-10, 3.1667, 4.5050000000000005e-10, 3.2333, 4.741e-10, 3.3, 8.061e-10)
V3A PULLUP_REFA VCC 0
B3A DIEA PULLUP_REFA I={V(KUA)*pwl(V(DIEA,VSS), -3.3, -0.03771, -3.2, -0.03767, -3.1000000000000005, -0.03764, -3.0, -0.0376, -2.9000000000000004, -0.03757, -2.8, -0.03754, -2.7, -0.0375, -2.6000000000000005, -0.037469999999999996, -2.5, -0.03743, -2.4000000000000004, -0.03739, -2.3, -0.03736, -2.2, -0.03732, -2.1000000000000005, -0.03728, -2.0, -0.03725, -1.9000000000000004, -0.03721, -1.7999999999999998, -0.03717, -1.7000000000000002, -0.03713, -1.6000000000000005, -0.037090000000000005, -1.5, -0.03705, -1.4000000000000004, -0.03701, -1.2999999999999998, -0.03697, -1.2000000000000002, -0.03693, -1.1000000000000005, -0.03688, -1.0, -0.03683, -0.9000000000000004, -0.03679, -0.7999999999999998, -0.03674, -0.7000000000000002, -0.0367, -0.6000000000000001, -0.036637, -0.5, -0.036590000000000004, -0.40000000000000036, -0.036535, -0.30000000000000027, -0.03647, -0.20000000000000018, -0.0364175, -0.10000000000000009, -0.03635, 0.0, -0.03628, 0.09999999999999964, -0.03621, 0.19999999999999973, -0.03613, 0.2999999999999998, -0.03604, 0.3999999999999999, -0.03595, 0.5, -0.035840000000000004, 0.5999999999999996, -0.0357, 0.6999999999999997, -0.03553, 0.7999999999999998, -0.03531, 0.8999999999999999, -0.03501, 1.0, -0.03463, 1.0999999999999996, -0.03415, 1.1999999999999997, -0.03358, 1.2999999999999998, -0.032920000000000005, 1.4, -0.032170000000000004, 1.4999999999999998, -0.03132, 1.5999999999999999, -0.03037, 1.6999999999999997, -0.02933, 1.7999999999999998, -0.0282, 1.9, -0.02697, 1.9999999999999998, -0.02565, 2.0999999999999996, -0.02423, 2.1999999999999997, -0.02272, 2.3, -0.02112, 2.4, -0.019420000000000003, 2.5, -0.01763, 2.5999999999999996, -0.01575, 2.6999999999999997, -0.013779999999999999, 2.8, -0.011710000000000002, 2.9, -0.009552, 3.0, -0.007301, 3.0999999999999996, -0.004959, 3.1999999999999997, -0.002525, 3.3, 0.0, 3.4, 0.002606, 3.5, 0.005277700000000001, 3.5999999999999996, 0.0080044, 3.6999999999999997, 0.010737700000000001, 3.8, 0.01336, 3.9, 0.0158366, 4.0, 0.01823, 4.1, 0.020553000000000002, 4.2, 0.022826000000000003, 4.3, 0.025063, 4.4, 0.027257000000000003, 4.5, 0.029434000000000002, 4.6, 0.031604, 4.699999999999999, 0.033756999999999995, 4.8, 0.0359, 4.9, 0.03805, 5.0, 0.04021, 5.1, 0.042350000000000006, 5.199999999999999, 0.0445, 5.3, 0.04664, 5.4, 0.04877, 5.5, 0.05087, 5.6, 0.05294, 5.699999999999999, 0.0548, 5.8, 0.05597, 5.9, 0.056780000000000004, 6.0, 0.05727, 6.1, 0.0574, 6.199999999999999, 0.05726, 6.3, 0.056729999999999996, 6.4, 0.055810000000000005, 6.5, 0.054520000000000006, 6.6, 0.0529)}
V4A PULLDOWN_REFA VSS 0
B4A DIEA PULLDOWN_REFA I={V(KDA)*pwl(V(DIEA,VSS), -3.3, -0.01411, -3.2, -0.01551, -3.1, -0.01709, -3.0, -0.01887, -2.9, -0.020890000000000002, -2.8, -0.023170000000000003, -2.7, -0.02573, -2.6, -0.028620000000000003, -2.5, -0.03185, -2.4, -0.03545, -2.3, -0.0394, -2.2, -0.04369, -2.1, -0.04821, -2.0, -0.05274, -1.9, -0.057170000000000006, -1.8, -0.06089, -1.7, -0.06362, -1.6, -0.06458, -1.5, -0.06358, -1.4, -0.06179, -1.3, -0.05787, -1.2, -0.0523, -1.1, -0.04607, -1.0, -0.039619999999999995, -0.9, -0.03383, -0.8, -0.02926, -0.7, -0.02574, -0.6, -0.022797, -0.5, -0.019899999999999998, -0.4, -0.016605, -0.3, -0.01277, -0.2, -0.0083195, -0.1, -0.004084, 0.0, 0.0, 0.1, 0.004004, 0.2, 0.007826, 0.3, 0.011470000000000001, 0.4, 0.01493, 0.5, 0.01822, 0.6, 0.02134, 0.7, 0.02429, 0.8, 0.02707, 0.9, 0.02968, 1.0, 0.032130000000000006, 1.1, 0.03442, 1.2, 0.03655, 1.3, 0.038520000000000006, 1.4, 0.04033, 1.5, 0.042, 1.6, 0.043500000000000004, 1.7, 0.04486, 1.8, 0.04607, 1.9, 0.047119999999999995, 2.0, 0.04802000000000001, 2.1, 0.04876, 2.2, 0.04933, 2.3, 0.04975, 2.4, 0.05005, 2.5, 0.05026, 2.6, 0.05042, 2.7, 0.05055, 2.8, 0.05065, 2.9, 0.05074, 3.0, 0.05081, 3.1, 0.05088, 3.2, 0.05094, 3.3, 0.051000000000000004, 3.4, 0.05105, 3.5, 0.0510997, 3.6, 0.0511444, 3.7, 0.0511877, 3.8, 0.05124, 3.9, 0.051276600000000006, 4.0, 0.051320000000000005, 4.1, 0.051363, 4.2, 0.051396000000000004, 4.3, 0.051442999999999996, 4.4, 0.051476999999999995, 4.5, 0.051514000000000004, 4.6, 0.051554, 4.7, 0.051587, 4.8, 0.05162, 4.9, 0.05166, 5.0, 0.0517, 5.1, 0.05174, 5.2, 0.05176, 5.3, 0.05181, 5.4, 0.051840000000000004, 5.5, 0.05187, 5.6, 0.05191, 5.7, 0.05194, 5.8, 0.05197, 5.9, 0.05201, 6.0, 0.05205, 6.1, 0.05207, 6.2, 0.05206, 6.3, 0.05213, 6.4, 0.05221, 6.5, 0.05222, 6.6, 0.0522)}
RLOADA OUTA VSS 50
CLOADA OUTA VSS 2p
BKUONB KUONB 0 V = pwl(min(max(V(GUPB), 0), 1), 0.0, 3.0093921634162756e-06, 0.0125, 0.05228750725535794, 0.025, 0.05473144254378619, 0.037500000000000006, 0.05694942046171046, 0.05, 0.0594729230268018, 0.0625, 0.06191050032241303, 0.07500000000000001, 0.06417867005234057, 0.08750000000000001, 0.06683172310613945, 0.1, 0.06893191714565297, 0.1125, 0.07289923298818231, 0.125, 0.07731203956560528, 0.1375, 0.08043810307856031, 0.15000000000000002, 0.08410618091017324, 0.1625, 0.08643811503597193, 0.17500000000000002, 0.08938852473411917, 0.1875, 0.0937848651286308, 0.2, 0.10623487896441042, 0.21250000000000002, 0.1133418350772213, 0.225, 0.11998834287165722, 0.23750000000000002, 0.1253154981847289, 0.25, 0.1303854409563551, 0.2625, 0.13849525171344862, 0.275, 0.1727016726609013, 0.28750000000000003, 0.1867356948981539, 0.30000000000000004, 0.2037520099670899, 0.3125, 0.2190844856073046, 0.325, 0.2336866364414111, 0.3375, 0.26773641055704833, 0.35000000000000003, 0.2981260578661715, 0.36250000000000004, 0.3243664804008222, 0.375, 0.3495783188150553, 0.3875, 0.3642024126847436, 0.4, 0.3648475476937759, 0.41250000000000003, 0.3821635034580908, 0.42500000000000004, 0.39804672358091986, 0.4375, 0.41515315416854426, 0.45, 0.43435193572389874, 0.4625, 0.44548912403938934, 0.47500000000000003, 0.4614388573206766, 0.48750000000000004, 0.4734714972338381, 0.5, 0.48118513240897204, 0.5125000000000001, 0.49375016762660684, 0.525, 0.5086829426520645, 0.5375, 0.5232351460021714, 0.55, 0.5345357321658584, 0.5625, 0.5477710363618739, 0.5750000000000001, 0.5618937002213381, 0.5875, 0.5765049687385937, 0.6000000000000001, 0.5917548488649643, 0.6125, 0.6051829124154585, 0.625, 0.6201118854553043, 0.6375000000000001, 0.6345202011229166, 0.65, 0.6495763130877753, 0.6625000000000001, 0.6663222794216381, 0.675, 0.6820919312587257, 0.6875, 0.6965680857205023, 0.7000000000000001, 0.7129231353150218, 0.7125, 0.7297114646249641, 0.7250000000000001, 0.7470059314439111, 0.7375, 0.7610331070375654, 0.75, 0.7762805198073346, 0.7625000000000001, 0.7943231518328329, 0.775, 0.8121843277705059, 0.7875000000000001, 0.8215595088484473, 0.8, 0.8371586279051473, 0.8125, 0.8508366287742789, 0.8250000000000001, 0.8676891707453597, 0.8375, 0.8790348976352548, 0.8500000000000001, 0.8907300138393146, 0.8625, 0.9042702710677536, 0.875, 0.916574173653605, 0.8875000000000001, 0.9278777680724882, 0.9, 0.9375792755328698, 0.9125000000000001, 0.9449786416425654, 0.925, 0.9568110791625042, 0.9375, 0.9677404047774579, 0.9500000000000001, 0.9735839547909003, 0.9625, 0.9873260635838413, 0.9750000000000001, 0.9890850427980586, 0.9875, 0.9966945057747306, 1.0, 0.9954751204465254)
BKUOFFB KUOFFB 0 V = pwl(min(max(V(GUPB), 0), 1), 0.0, 3.0093921634162756e-06, 0.0125, -0.0022740802533943055, 0.025, 0.029417165566120222, 0.037500000000000006, 0.041208673921319675, 0.05, 0.04475078297130246, 0.0625, 0.07098024046400916, 0.07500000000000001, 0.07741913867904851, 0.08750000000000001, 0.07874556587711407, 0.1, 0.09731196911044823, 0.1125, 0.12110585930658176, 0.125, 0.14077328207908307, 0.1375, 0.14417823966331292, 0.15000000000000002, 0.14419249382195165, 0.1625, 0.15579989154463436, 0.17500000000000002, 0.17633347745133762, 0.1875, 0.19918972825476444, 0.2, 0.2256193773962982, 0.21250000000000002, 0.2434153507411666, 0.225, 0.2550398210969347, 0.23750000000000002, 0.24884746218272497, 0.25, 0.24991800768539454, 0.2625, 0.2639645415910423, 0.275, 0.276133800935059, 0.28750000000000003, 0.2901351268715241, 0.30000000000000004, 0.30915703180539084, 0.3125, 0.332201666623121, 0.325, 0.34621416695020113, 0.3375, 0.3589676006595363, 0.35000000000000003, 0.3684945269589724, 0.36250000000000004, 0.3661627367798748, 0.375, 0.373699158340551, 0.3875, 0.3867081547890766, 0.4, 0.4009040819255699, 0.41250000000000003, 0.41932414540329604, 0.42500000000000004, 0.44625381060717145, 0.4375, 0.46751017239711473, 0.45, 0.4838832240902737, 0.4625, 0.49578922052631086, 0.47500000000000003, 0.5052318043069666, 0.48750000000000004, 0.5080216178577868, 0.5, 0.5071931985289652, 0.5125000000000001, 0.5152044705693055, 0.525, 0.531875327909723, 0.5375, 0.549669150327503, 0.55, 0.5703369119551978, 0.5625, 0.5910046735828924, 0.5750000000000001, 0.614461308074367, 0.5875, 0.6381130743410517, 0.6000000000000001, 0.6539714841346385, 0.6125, 0.6606583916685312, 0.625, 0.6673452992024239, 0.6375000000000001, 0.6675051225163636, 0.65, 0.6664968576132405, 0.6625000000000001, 0.6665103425594637, 0.675, 0.6764172302084827, 0.6875, 0.6863241178575016, 0.7000000000000001, 0.6993367403104283, 0.7125, 0.7257885770727429, 0.7250000000000001, 0.7522404138350578, 0.7375, 0.7759341074002183, 0.75, 0.779817954105221, 0.7625000000000001, 0.7837018008102237, 0.775, 0.7875856475152263, 0.7875000000000001, 0.7795233095520633, 0.8, 0.7699594175910418, 0.8125, 0.7603955256300203, 0.8250000000000001, 0.7682453081276739, 0.8375, 0.7951997754871764, 0.8500000000000001, 0.8221542428466792, 0.8625, 0.8491087102061816, 0.875, 0.8579263679975605, 0.8875000000000001, 0.864223306289378, 0.9, 0.8705202445811956, 0.9125000000000001, 0.8759421131111564, 0.925, 0.8714935212825247, 0.9375, 0.867044929453893, 0.9500000000000001, 0.8625963376252612, 0.9625, 0.8629967341120316, 0.9750000000000001, 0.922041524008766, 0.9875, 0.9810863139055, 1.0, 0.9954751204465254)
BKUB KUB 0 V = (V(GUPTARGET) >= V(GUPB)) ? V(KUONB) : V(KUOFFB)
BKDONB KDONB 0 V = pwl(min(max(V(GDNB), 0), 1), 0.0, 4.734612809328741e-08, 0.0125, 0.05329236484759367, 0.025, 0.05592169527131164, 0.037500000000000006, 0.05860503093416337, 0.05, 0.06192463935811757, 0.0625, 0.06616776156175838, 0.07500000000000001, 0.07127020676008339, 0.08750000000000001, 0.07664534704163428, 0.1, 0.08159526091120332, 0.1125, 0.09068545347124693, 0.125, 0.10432136181993282, 0.1375, 0.11217859876232435, 0.15000000000000002, 0.1182859980897553, 0.1625, 0.12246727248289223, 0.17500000000000002, 0.12905993884456868, 0.1875, 0.13435731995448283, 0.2, 0.13749442061316336, 0.21250000000000002, 0.1451352774351428, 0.225, 0.1504826730552962, 0.23750000000000002, 0.1551080436124774, 0.25, 0.16268982060625972, 0.2625, 0.18311624575052796, 0.275, 0.19936530913391662, 0.28750000000000003, 0.21030174466734777, 0.30000000000000004, 0.21878783626418608, 0.3125, 0.2274574134824358, 0.325, 0.23628721756434404, 0.3375, 0.2444067787068425, 0.35000000000000003, 0.2533371580638324, 0.36250000000000004, 0.26572143746566984, 0.375, 0.2842671775800465, 0.3875, 0.3091399689527781, 0.4, 0.3203906864815231, 0.41250000000000003, 0.3336544607784517, 0.42500000000000004, 0.3466905933519557, 0.4375, 0.3600060451476511, 0.45, 0.38250177617373204, 0.4625, 0.39963266837509626, 0.47500000000000003, 0.40357968468733874, 0.48750000000000004, 0.4189293882721403, 0.5, 0.4340118617625959, 0.5125000000000001, 0.4493780935085833, 0.525, 0.4681469566705732, 0.5375, 0.48896563115025043, 0.55, 0.5051973559321297, 0.5625, 0.5266300282737097, 0.5750000000000001, 0.545797012892126, 0.5875, 0.5669863776375242, 0.6000000000000001, 0.5883523215028394, 0.6125, 0.6102267343270952, 0.625, 0.6228207368472676, 0.6375000000000001, 0.6416973961388471, 0.65, 0.6676057419657759, 0.6625000000000001, 0.6930517199989947, 0.675, 0.720077011120205, 0.6875, 0.7468837461673431, 0.7000000000000001, 0.7537720936503999, 0.7125, 0.7814580000048994, 0.7250000000000001, 0.8114384435642582, 0.7375, 0.8446200515351998, 0.75, 0.8502914687301576, 0.7625000000000001, 0.8595681290663328, 0.775, 0.8833376517019619, 0.7875000000000001, 0.9089337898629851, 0.8, 0.9301369864272714, 0.8125, 0.9217607180135138, 0.8250000000000001, 0.9362729413727154, 0.8375, 0.9520320809305952, 0.8500000000000001, 0.9531743375214106, 0.8625, 0.9628214532174169, 0.875, 0.9734256255523317, 0.8875000000000001, 0.9749777035023779, 0.9, 0.9804983662074728, 0.9125000000000001, 0.9849537531782325, 0.925, 0.9875221242825095, 0.9375, 0.9925942194348838, 0.9500000000000001, 0.9956033021545923, 0.9625, 0.9963845565173853, 0.9750000000000001, 0.9980287476869627, 0.9875, 0.9996404045718792, 1.0, 1.0008237983799224)
BKDOFFB KDOFFB 0 V = pwl(min(max(V(GDNB), 0), 1), 0.0, 4.734612809328741e-08, 0.0125, 0.014064222783434171, 0.025, 0.014733707008303135, 0.037500000000000006, 0.01677512272559132, 0.05, 0.023204673256761052, 0.0625, 0.028554756800513014, 0.07500000000000001, 0.03814518291689158, 0.08750000000000001, 0.039218698095390365, 0.1, 0.05376346386716841, 0.1125, 0.05564312016995136, 0.125, 0.07171654463865561, 0.1375, 0.07956733246885798, 0.15000000000000002, 0.09046044752102987, 0.1625, 0.10999639745338995, 0.17500000000000002, 0.12803964284848068, 0.1875, 0.1387333192307466, 0.2, 0.1479701252887331, 0.21250000000000002, 0.16441791439868844, 0.225, 0.18019434514432778, 0.23750000000000002, 0.17795796412176285, 0.25, 0.19933092682632264, 0.2625, 0.22040554074558202, 0.275, 0.2393888362497798, 0.28750000000000003, 0.2459954388895755, 0.30000000000000004, 0.26706649658870724, 0.3125, 0.2853568065798054, 0.325, 0.302073068512964, 0.3375, 0.32291825675049185, 0.35000000000000003, 0.34267303215998873, 0.36250000000000004, 0.36069288998617083, 0.375, 0.3798680393506801, 0.3875, 0.3997735650314865, 0.4, 0.4181429394974808, 0.41250000000000003, 0.43633404204578286, 0.42500000000000004, 0.4543308052332155, 0.4375, 0.4722127666433587, 0.45, 0.49330535696798083, 0.4625, 0.5096890496389063, 0.47500000000000003, 0.530030567321489, 0.48750000000000004, 0.547021926501666, 0.5, 0.5630654900586055, 0.5125000000000001, 0.5791156091175842, 0.525, 0.5956807446959247, 0.5375, 0.6093276570863156, 0.55, 0.6385269244213276, 0.5625, 0.6591248931844897, 0.5750000000000001, 0.6746229781737704, 0.5875, 0.6880926247133184, 0.6000000000000001, 0.7003363626197371, 0.6125, 0.7237565394862068, 0.625, 0.7512205757602135, 0.6375000000000001, 0.7669386055815546, 0.65, 0.7765505065694908, 0.6625000000000001, 0.7847129233988287, 0.675, 0.7926150524946639, 0.6875, 0.8005433333475432, 0.7000000000000001, 0.8085735285479029, 0.7125, 0.8167683054576113, 0.7250000000000001, 0.8264709461234827, 0.7375, 0.8381788441066993, 0.75, 0.8578407871752743, 0.7625000000000001, 0.8698051839926956, 0.775, 0.8757725898657829, 0.7875000000000001, 0.8798005793477042, 0.8, 0.8842942269186163, 0.8125, 0.8891936971246026, 0.8250000000000001, 0.8931033121444052, 0.8375, 0.8976641135683293, 0.8500000000000001, 0.9035193281196118, 0.8625, 0.912966815081816, 0.875, 0.923968820041983, 0.8875000000000001, 0.9272938541394216, 0.9, 0.930593018329846, 0.9125000000000001, 0.9338210469884203, 0.925, 0.9362369536268493, 0.9375, 0.9378013356381388, 0.9500000000000001, 0.9401984251963456, 0.9625, 0.9430139937342643, 0.9750000000000001, 0.9457162600349911, 0.9875, 0.9483897962387776, 1.0, 1.0008237983799224)
BKDB KDB 0 V = (V(GDNTARGET) >= V(GDNB)) ? V(KDONB) : V(KDOFFB)
R1B OUTB MIDB {R_pkg}
L1B DIEB MIDB {L_pkg}
C1B OUTB VSS {C_pkg}
C2B DIEB VSS {C_comp}
V1B PWR_CLAMP_REFB VCC 0
B1B DIEB PWR_CLAMP_REFB I = pwl(V(DIEB,VSS), 3.3, 8.061e-10, 3.3333, 1.728e-09, 3.3667, 4.351e-09, 3.4, 1.2400000000000002e-08, 3.4333, 3.6880000000000003e-08, 3.4667, 1.087e-07, 3.5, 3.103e-07, 3.5332999999999997, 8.498999999999999e-07, 3.5667, 2.229e-06, 3.5999999999999996, 5.612e-06, 3.6332999999999998, 1.35e-05, 3.6666999999999996, 3.039e-05, 3.6999999999999997, 6.227e-05, 3.7333, 0.0001146, 3.7666999999999997, 0.0001905, 3.8, 0.00029, 3.8333, 0.00041170000000000003, 3.8667, 0.0005534, 3.9, 0.0007134000000000001, 3.9333, 0.0008901, 3.9667, 0.001083, 4.0, 0.0012900000000000001, 4.0333, 0.001512, 4.0667, 0.001747, 4.1, 0.001997, 4.1333, 0.00226, 4.1667, 0.002536, 4.2, 0.0028239999999999997, 4.2333, 0.003126, 4.2667, 0.00344, 4.3, 0.003767, 4.3332999999999995, 0.004107, 4.3667, 0.004458999999999999, 4.4, 0.004823000000000001, 4.4333, 0.005198, 4.4666999999999994, 0.005586000000000001, 4.5, 0.005986, 4.5333, 0.006397000000000001, 4.5667, 0.0068200000000000005, 4.6, 0.007256, 4.6333, 0.007703000000000001, 4.6667, 0.008162, 4.699999999999999, 0.008633, 4.7333, 0.009115999999999999, 4.7667, 0.009611000000000001, 4.8, 0.010119999999999999, 4.8332999999999995, 0.01064, 4.8667, 0.01117, 4.9, 0.011720000000000001, 4.9333, 0.01228, 4.9666999999999994, 0.01285, 5.0, 0.01343, 5.0333, 0.014029999999999999, 5.0667, 0.01465, 5.1, 0.01527, 5.1333, 0.01592, 5.1667, 0.01657, 5.199999999999999, 0.01725, 5.2333, 0.01793, 5.2667, 0.01864, 5.3, 0.01936, 5.3332999999999995, 0.020100000000000003, 5.3667, 0.02086, 5.4, 0.02163, 5.4333, 0.02243, 5.4666999999999994, 0.02324, 5.5, 0.024079999999999997, 5.5333, 0.02493, 5.5667, 0.02581, 5.6, 0.02671, 5.6333, 0.02764, 5.6667, 0.028579999999999998, 5.699999999999999, 0.02956, 5.7333, 0.03056, 5.7667, 0.03158, 5.8, 0.03264, 5.8332999999999995, 0.03372, 5.8667, 0.03483, 5.9, 0.03598, 5.9333, 0.03716, 5.9666999999999994, 0.03837, 6.0, 0.039619999999999995, 6.0333, 0.040909999999999995, 6.0667, 0.04223, 6.1, 0.0436, 6.1333, 0.045, 6.1667, 0.046450000000000005, 6.199999999999999, 0.047939999999999997, 6.2333, 0.04947, 6.2667, 0.05105, 6.3, 0.05267, 6.3332999999999995, 0.054340000000000006, 6.3667, 0.05604, 6.4, 0.05779, 6.4333, 0.05958, 6.4666999999999994, 0.06141, 6.5, 0.06328, 6.5333, 0.06518, 6.5667, 0.06712, 6.6, 0.0691)
V2B GND_CLAMP_REFB VSS 0
B2B DIEB GND_CLAMP_REFB I = pwl(V(DIEB,VSS), -3.3, -0.034820000000000004, -3.2333, -0.03558, -3.1667, -0.03637, -3.1, -0.03718, -3.0333, -0.038020000000000005, -2.9667, -0.0389, -2.9, -0.039799999999999995, -2.8333, -0.040729999999999995, -2.7667, -0.0417, -2.7, -0.04269, -2.6333, -0.04372, -2.5667, -0.044770000000000004, -2.5, -0.04585, -2.4333, -0.04696, -2.3667, -0.04808, -2.3, -0.049229999999999996, -2.2333, -0.05038, -2.1667, -0.05154, -2.1, -0.05269, -2.0333, -0.053810000000000004, -1.9667, -0.0549, -1.9, -0.05593, -1.8333, -0.05687, -1.7667, -0.0577, -1.7, -0.05838, -1.6333, -0.05886, -1.5667, -0.059090000000000004, -1.5, -0.05892, -1.4333, -0.05745, -1.3667, -0.05546, -1.3, -0.05303, -1.2333, -0.05013, -1.1667, -0.04675, -1.1, -0.04291, -1.0333, -0.03866, -0.9667, -0.03408, -0.9, -0.02929, -0.8333, -0.024440000000000003, -0.7667, -0.01968, -0.7, -0.01518, -0.6333, -0.0111, -0.5667, -0.007562, -0.5, -0.004690000000000001, -0.4333, -0.002529, -0.3667, -0.0010400000000000001, -0.3, -0.00021, -0.2333, -1.2199999999999998e-05, -0.1667, -5.128e-07, -0.1, -2.4280000000000003e-08, -0.033333, -1.662e-09, 0.033333, -1.016e-10, 0.1, -2.448e-11, 0.1667, -1.042e-11, 0.2333, -2.5530000000000003e-13, 0.3, 9.069e-12, 0.3667, 1.812e-11, 0.4333, 2.708e-11, 0.5, 3.601e-11, 0.5667, 4.4950000000000004e-11, 0.6333, 5.392e-11, 0.7, 6.293e-11, 0.7667, 7.198999999999999e-11, 0.8333, 8.11e-11, 0.9, 9.028e-11, 0.9667, 9.952e-11, 1.0333, 1.088e-10, 1.1, 1.1820000000000002e-10, 1.1667, 1.276e-10, 1.2333, 1.371e-10, 1.3, 1.467e-10, 1.3667, 1.563e-10, 1.4333, 1.661e-10, 1.5, 1.759e-10, 1.5667, 1.8570000000000002e-10, 1.6333, 1.9570000000000003e-10, 1.7, 2.057e-10, 1.7667, 2.158e-10, 1.8333, 2.2600000000000002e-10, 1.9, 2.363e-10, 1.9667, 2.466e-10, 2.0333, 2.5700000000000004e-10, 2.1, 2.675e-10, 2.1667, 2.7810000000000005e-10, 2.2333, 2.8880000000000003e-10, 2.3, 2.996e-10, 2.3667, 3.1040000000000003e-10, 2.4333, 3.2140000000000005e-10, 2.5, 3.324e-10, 2.5667, 3.4350000000000005e-10, 2.6333, 3.548e-10, 2.7, 3.661e-10, 2.7667, 3.7750000000000004e-10, 2.8333, 3.8900000000000005e-10, 2.9, 4.007e-10, 2.9667, 4.125e-10, 3.0333, 4.2450000000000003e-10, 3.1, 4.3690000000000006e-10, 3.1667, 4.5050000000000005e-10, 3.2333, 4.741e-10, 3.3, 8.061e-10)
V3B PULLUP_REFB VCC 0
B3B DIEB PULLUP_REFB I={V(KUB)*pwl(V(DIEB,VSS), -3.3, -0.03771, -3.2, -0.03767, -3.1000000000000005, -0.03764, -3.0, -0.0376, -2.9000000000000004, -0.03757, -2.8, -0.03754, -2.7, -0.0375, -2.6000000000000005, -0.037469999999999996, -2.5, -0.03743, -2.4000000000000004, -0.03739, -2.3, -0.03736, -2.2, -0.03732, -2.1000000000000005, -0.03728, -2.0, -0.03725, -1.9000000000000004, -0.03721, -1.7999999999999998, -0.03717, -1.7000000000000002, -0.03713, -1.6000000000000005, -0.037090000000000005, -1.5, -0.03705, -1.4000000000000004, -0.03701, -1.2999999999999998, -0.03697, -1.2000000000000002, -0.03693, -1.1000000000000005, -0.03688, -1.0, -0.03683, -0.9000000000000004, -0.03679, -0.7999999999999998, -0.03674, -0.7000000000000002, -0.0367, -0.6000000000000001, -0.036637, -0.5, -0.036590000000000004, -0.40000000000000036, -0.036535, -0.30000000000000027, -0.03647, -0.20000000000000018, -0.0364175, -0.10000000000000009, -0.03635, 0.0, -0.03628, 0.09999999999999964, -0.03621, 0.19999999999999973, -0.03613, 0.2999999999999998, -0.03604, 0.3999999999999999, -0.03595, 0.5, -0.035840000000000004, 0.5999999999999996, -0.0357, 0.6999999999999997, -0.03553, 0.7999999999999998, -0.03531, 0.8999999999999999, -0.03501, 1.0, -0.03463, 1.0999999999999996, -0.03415, 1.1999999999999997, -0.03358, 1.2999999999999998, -0.032920000000000005, 1.4, -0.032170000000000004, 1.4999999999999998, -0.03132, 1.5999999999999999, -0.03037, 1.6999999999999997, -0.02933, 1.7999999999999998, -0.0282, 1.9, -0.02697, 1.9999999999999998, -0.02565, 2.0999999999999996, -0.02423, 2.1999999999999997, -0.02272, 2.3, -0.02112, 2.4, -0.019420000000000003, 2.5, -0.01763, 2.5999999999999996, -0.01575, 2.6999999999999997, -0.013779999999999999, 2.8, -0.011710000000000002, 2.9, -0.009552, 3.0, -0.007301, 3.0999999999999996, -0.004959, 3.1999999999999997, -0.002525, 3.3, 0.0, 3.4, 0.002606, 3.5, 0.005277700000000001, 3.5999999999999996, 0.0080044, 3.6999999999999997, 0.010737700000000001, 3.8, 0.01336, 3.9, 0.0158366, 4.0, 0.01823, 4.1, 0.020553000000000002, 4.2, 0.022826000000000003, 4.3, 0.025063, 4.4, 0.027257000000000003, 4.5, 0.029434000000000002, 4.6, 0.031604, 4.699999999999999, 0.033756999999999995, 4.8, 0.0359, 4.9, 0.03805, 5.0, 0.04021, 5.1, 0.042350000000000006, 5.199999999999999, 0.0445, 5.3, 0.04664, 5.4, 0.04877, 5.5, 0.05087, 5.6, 0.05294, 5.699999999999999, 0.0548, 5.8, 0.05597, 5.9, 0.056780000000000004, 6.0, 0.05727, 6.1, 0.0574, 6.199999999999999, 0.05726, 6.3, 0.056729999999999996, 6.4, 0.055810000000000005, 6.5, 0.054520000000000006, 6.6, 0.0529)}
V4B PULLDOWN_REFB VSS 0
B4B DIEB PULLDOWN_REFB I={V(KDB)*pwl(V(DIEB,VSS), -3.3, -0.01411, -3.2, -0.01551, -3.1, -0.01709, -3.0, -0.01887, -2.9, -0.020890000000000002, -2.8, -0.023170000000000003, -2.7, -0.02573, -2.6, -0.028620000000000003, -2.5, -0.03185, -2.4, -0.03545, -2.3, -0.0394, -2.2, -0.04369, -2.1, -0.04821, -2.0, -0.05274, -1.9, -0.057170000000000006, -1.8, -0.06089, -1.7, -0.06362, -1.6, -0.06458, -1.5, -0.06358, -1.4, -0.06179, -1.3, -0.05787, -1.2, -0.0523, -1.1, -0.04607, -1.0, -0.039619999999999995, -0.9, -0.03383, -0.8, -0.02926, -0.7, -0.02574, -0.6, -0.022797, -0.5, -0.019899999999999998, -0.4, -0.016605, -0.3, -0.01277, -0.2, -0.0083195, -0.1, -0.004084, 0.0, 0.0, 0.1, 0.004004, 0.2, 0.007826, 0.3, 0.011470000000000001, 0.4, 0.01493, 0.5, 0.01822, 0.6, 0.02134, 0.7, 0.02429, 0.8, 0.02707, 0.9, 0.02968, 1.0, 0.032130000000000006, 1.1, 0.03442, 1.2, 0.03655, 1.3, 0.038520000000000006, 1.4, 0.04033, 1.5, 0.042, 1.6, 0.043500000000000004, 1.7, 0.04486, 1.8, 0.04607, 1.9, 0.047119999999999995, 2.0, 0.04802000000000001, 2.1, 0.04876, 2.2, 0.04933, 2.3, 0.04975, 2.4, 0.05005, 2.5, 0.05026, 2.6, 0.05042, 2.7, 0.05055, 2.8, 0.05065, 2.9, 0.05074, 3.0, 0.05081, 3.1, 0.05088, 3.2, 0.05094, 3.3, 0.051000000000000004, 3.4, 0.05105, 3.5, 0.0510997, 3.6, 0.0511444, 3.7, 0.0511877, 3.8, 0.05124, 3.9, 0.051276600000000006, 4.0, 0.051320000000000005, 4.1, 0.051363, 4.2, 0.051396000000000004, 4.3, 0.051442999999999996, 4.4, 0.051476999999999995, 4.5, 0.051514000000000004, 4.6, 0.051554, 4.7, 0.051587, 4.8, 0.05162, 4.9, 0.05166, 5.0, 0.0517, 5.1, 0.05174, 5.2, 0.05176, 5.3, 0.05181, 5.4, 0.051840000000000004, 5.5, 0.05187, 5.6, 0.05191, 5.7, 0.05194, 5.8, 0.05197, 5.9, 0.05201, 6.0, 0.05205, 6.1, 0.05207, 6.2, 0.05206, 6.3, 0.05213, 6.4, 0.05221, 6.5, 0.05222, 6.6, 0.0522)}
RLOADB OUTB VSS 50
CLOADB OUTB VSS 2p
.tran 1p 14.0n uic
.control
run
set filetype=ascii
write run.raw
quit
.endc
.end
