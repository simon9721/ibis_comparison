* Phase-1 direct-load PRBS7 HSPICE native IBIS
.title ex2 PRBS7 UI=0.6ns native IBIS
.option post=2 probe accurate ingold=2
.temp 27

Vin in_dig 0 PWL(
+ 0n 0
+ 5n 0
+ 5.05n 3.3
+ 9.2n 3.3
+ 9.25n 0
+ 12.8n 0
+ 12.85n 3.3
+ 13.4n 3.3
+ 13.45n 0
+ 16.4n 0
+ 16.45n 3.3
+ 17.6n 3.3
+ 17.65n 0
+ 20n 0
+ 20.05n 3.3
+ 20.6n 3.3
+ 20.65n 0
+ 21.2n 0
+ 21.25n 3.3
+ 21.8n 3.3
+ 21.85n 0
+ 23.6n 0
+ 23.65n 3.3
+ 26n 3.3
+ 26.05n 0
+ 27.2n 0
+ 27.25n 3.3
+ 27.8n 3.3
+ 27.85n 0
+ 29.6n 0
+ 29.65n 3.3
+ 30.2n 3.3
+ 30.25n 0
+ 30.8n 0
+ 30.85n 3.3
+ 32n 3.3
+ 32.05n 0
+ 33.2n 0
+ 33.25n 3.3
+ 35n 3.3
+ 35.05n 0
+ 35.6n 0
+ 35.65n 3.3
+ 36.2n 3.3
+ 36.25n 0
+ 36.8n 0
+ 36.85n 3.3
+ 37.4n 3.3
+ 37.45n 0
+ 38.6n 0
+ 38.65n 3.3
+ 41.6n 3.3
+ 41.65n 0
+ 42.2n 0
+ 42.25n 3.3
+ 42.8n 3.3
+ 42.85n 0
+ 45.2n 0
+ 45.25n 3.3
+ 47n 3.3
+ 47.05n 0
+ 48.8n 0
+ 48.85n 3.3
+ 49.4n 3.3
+ 49.45n 0
+ 50.6n 0
+ 50.65n 3.3
+ 51.2n 3.3
+ 51.25n 0
+ 52.4n 0
+ 52.45n 3.3
+ 53.6n 3.3
+ 53.65n 0
+ 54.2n 0
+ 54.25n 3.3
+ 55.4n 3.3
+ 55.45n 0
+ 56n 0
+ 56.05n 3.3
+ 56.6n 3.3
+ 56.65n 0
+ 57.2n 0
+ 57.25n 3.3
+ 58.4n 3.3
+ 58.45n 0
+ 59n 0
+ 59.05n 3.3
+ 61.4n 3.3
+ 61.45n 0
+ 62n 0
+ 62.05n 3.3
+ 63.2n 3.3
+ 63.25n 0
+ 65n 0
+ 65.05n 3.3
+ 66.2n 3.3
+ 66.25n 0
+ 66.8n 0
+ 66.85n 3.3
+ 67.4n 3.3
+ 67.45n 0
+ 68.6n 0
+ 68.65n 3.3
+ 69.2n 3.3
+ 69.25n 0
+ 69.8n 0
+ 69.85n 3.3
+ 71.6n 3.3
+ 71.65n 0
+ 72.2n 0
+ 72.25n 3.3
+ 74n 3.3
+ 74.05n 0
+ 75.2n 0
+ 75.25n 3.3
+ 76.4n 3.3
+ 76.45n 0
+ 77.6n 0
+ 77.65n 3.3
+ 78.2n 3.3
+ 78.25n 0
+ 78.8n 0
+ 78.85n 3.3
+ 79.4n 3.3
+ 79.45n 0
+ 80n 0
+ 80.05n 3.3
+ 80.6n 3.3
+ 80.65n 0
+ 81.2n 0
+ 81.25n 3.3
+ 85.4n 3.3
+ 85.45n 0
+ 89n 0
+ 89.05n 3.3
+ 89.6n 3.3
+ 89.65n 0
+ 92.6n 0
+ 92.65n 3.3
+ 93.8n 3.3
+ 93.85n 0
+ 96.2n 0
+ 96.25n 3.3
+ 96.8n 3.3
+ 96.85n 0
+ 97.4n 0
+ 97.45n 3.3
+ 98n 3.3
+ 98.05n 0
+ 99.8n 0
+ 99.85n 3.3
+ 102.2n 3.3
+ 102.25n 0
+ 103.4n 0
+ 103.45n 3.3
+ 104n 3.3
+ 104.05n 0
+ 105.8n 0
+ 105.85n 3.3
+ 106.4n 3.3
+ 106.45n 0
+ 107n 0
+ 107.05n 3.3
+ 108.2n 3.3
+ 108.25n 0
+ 109.4n 0
+ 109.45n 3.3
+ 111.2n 3.3
+ 111.25n 0
+ 111.8n 0
+ 111.85n 3.3
+ 112.4n 3.3
+ 112.45n 0
+ 113n 0
+ 113.05n 3.3
+ 113.6n 3.3
+ 113.65n 0
+ 114.8n 0
+ 114.85n 3.3
+ 117.8n 3.3
+ 117.85n 0
+ 118.4n 0
+ 118.45n 3.3
+ 119n 3.3
+ 119.05n 0
+ 121.4n 0
+ 121.45n 3.3
+ 123.2n 3.3
+ 123.25n 0
+ 125n 0
+ 125.05n 3.3
+ 125.6n 3.3
+ 125.65n 0
+ 126.8n 0
+ 126.85n 3.3
+ 127.4n 3.3
+ 127.45n 0
+ 128.6n 0
+ 128.65n 3.3
+ 129.8n 3.3
+ 129.85n 0
+ 130.4n 0
+ 130.45n 3.3
+ 131.6n 3.3
+ 131.65n 0
+ 132.2n 0
+ 132.25n 3.3
+ 132.8n 3.3
+ 132.85n 0
+ 133.4n 0
+ 133.45n 3.3
+ 134.6n 3.3
+ 134.65n 0
+ 135.2n 0
+ 135.25n 3.3
+ 137.6n 3.3
+ 137.65n 0
+ 138.2n 0
+ 138.25n 3.3
+ 139.4n 3.3
+ 139.45n 0
+ 141.2n 0
+ 141.25n 3.3
+ 142.4n 3.3
+ 142.45n 0
+ 143n 0
+ 143.05n 3.3
+ 143.6n 3.3
+ 143.65n 0
+ 144.8n 0
+ 144.85n 3.3
+ 145.4n 3.3
+ 145.45n 0
+ 146n 0
+ 146.05n 3.3
+ 147.8n 3.3
+ 147.85n 0
+ 148.4n 0
+ 148.45n 3.3
+ 150.2n 3.3
+ 150.25n 0
+ 151.4n 0
+ 151.45n 3.3
+ 152.6n 3.3
+ 152.65n 0
+ 153.8n 0
+ 153.85n 3.3
+ 154.4n 3.3
+ 154.45n 0
+ 155n 0
+ 155.05n 3.3
+ 155.6n 3.3
+ 155.65n 0
+ 156.2n 0
+ 156.25n 3.3
+ 156.8n 3.3
+ 156.85n 0
+ 157.4n 0
+ 165.4n 0 )

VPU pu_ref 0 DC 3.3
VPD pd_ref 0 DC 0
VPC pc_ref 0 DC 3.3
VGC gc_ref 0 DC 0
BIBIS pu_ref pd_ref pad_ibis in_dig pc_ref gc_ref
+ file='input.ibs' model='driver' buffer=2 typ=typ power=off interpol=1
+ ramp_rwf=2 ramp_fwf=2 xv_pu=ku xv_pd=kd
Rload pad_ibis 0 50
Cload pad_ibis 0 2p

.probe tran V(in_dig) V(pad_ibis) V(ku) V(kd)
.tran 0.005n 165.4n
.end
