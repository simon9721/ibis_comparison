* Phase-1 direct-load PRBS7 transistor reference
.title ex2 PRBS7 UI=0.75ns transistor
.option post=2 probe accurate ingold=2
.temp 27

Vin in_dig 0 PWL(
+ 0n 0
+ 5n 0
+ 5.05n 3.3
+ 10.25n 3.3
+ 10.3n 0
+ 14.75n 0
+ 14.8n 3.3
+ 15.5n 3.3
+ 15.55n 0
+ 19.25n 0
+ 19.3n 3.3
+ 20.75n 3.3
+ 20.8n 0
+ 23.75n 0
+ 23.8n 3.3
+ 24.5n 3.3
+ 24.55n 0
+ 25.25n 0
+ 25.3n 3.3
+ 26n 3.3
+ 26.05n 0
+ 28.25n 0
+ 28.3n 3.3
+ 31.25n 3.3
+ 31.3n 0
+ 32.75n 0
+ 32.8n 3.3
+ 33.5n 3.3
+ 33.55n 0
+ 35.75n 0
+ 35.8n 3.3
+ 36.5n 3.3
+ 36.55n 0
+ 37.25n 0
+ 37.3n 3.3
+ 38.75n 3.3
+ 38.8n 0
+ 40.25n 0
+ 40.3n 3.3
+ 42.5n 3.3
+ 42.55n 0
+ 43.25n 0
+ 43.3n 3.3
+ 44n 3.3
+ 44.05n 0
+ 44.75n 0
+ 44.8n 3.3
+ 45.5n 3.3
+ 45.55n 0
+ 47n 0
+ 47.05n 3.3
+ 50.75n 3.3
+ 50.8n 0
+ 51.5n 0
+ 51.55n 3.3
+ 52.25n 3.3
+ 52.3n 0
+ 55.25n 0
+ 55.3n 3.3
+ 57.5n 3.3
+ 57.55n 0
+ 59.75n 0
+ 59.8n 3.3
+ 60.5n 3.3
+ 60.55n 0
+ 62n 0
+ 62.05n 3.3
+ 62.75n 3.3
+ 62.8n 0
+ 64.25n 0
+ 64.3n 3.3
+ 65.75n 3.3
+ 65.8n 0
+ 66.5n 0
+ 66.55n 3.3
+ 68n 3.3
+ 68.05n 0
+ 68.75n 0
+ 68.8n 3.3
+ 69.5n 3.3
+ 69.55n 0
+ 70.25n 0
+ 70.3n 3.3
+ 71.75n 3.3
+ 71.8n 0
+ 72.5n 0
+ 72.55n 3.3
+ 75.5n 3.3
+ 75.55n 0
+ 76.25n 0
+ 76.3n 3.3
+ 77.75n 3.3
+ 77.8n 0
+ 80n 0
+ 80.05n 3.3
+ 81.5n 3.3
+ 81.55n 0
+ 82.25n 0
+ 82.3n 3.3
+ 83n 3.3
+ 83.05n 0
+ 84.5n 0
+ 84.55n 3.3
+ 85.25n 3.3
+ 85.3n 0
+ 86n 0
+ 86.05n 3.3
+ 88.25n 3.3
+ 88.3n 0
+ 89n 0
+ 89.05n 3.3
+ 91.25n 3.3
+ 91.3n 0
+ 92.75n 0
+ 92.8n 3.3
+ 94.25n 3.3
+ 94.3n 0
+ 95.75n 0
+ 95.8n 3.3
+ 96.5n 3.3
+ 96.55n 0
+ 97.25n 0
+ 97.3n 3.3
+ 98n 3.3
+ 98.05n 0
+ 98.75n 0
+ 98.8n 3.3
+ 99.5n 3.3
+ 99.55n 0
+ 100.25n 0
+ 100.3n 3.3
+ 105.5n 3.3
+ 105.55n 0
+ 110n 0
+ 110.05n 3.3
+ 110.75n 3.3
+ 110.8n 0
+ 114.5n 0
+ 114.55n 3.3
+ 116n 3.3
+ 116.05n 0
+ 119n 0
+ 119.05n 3.3
+ 119.75n 3.3
+ 119.8n 0
+ 120.5n 0
+ 120.55n 3.3
+ 121.25n 3.3
+ 121.3n 0
+ 123.5n 0
+ 123.55n 3.3
+ 126.5n 3.3
+ 126.55n 0
+ 128n 0
+ 128.05n 3.3
+ 128.75n 3.3
+ 128.8n 0
+ 131n 0
+ 131.05n 3.3
+ 131.75n 3.3
+ 131.8n 0
+ 132.5n 0
+ 132.55n 3.3
+ 134n 3.3
+ 134.05n 0
+ 135.5n 0
+ 135.55n 3.3
+ 137.75n 3.3
+ 137.8n 0
+ 138.5n 0
+ 138.55n 3.3
+ 139.25n 3.3
+ 139.3n 0
+ 140n 0
+ 140.05n 3.3
+ 140.75n 3.3
+ 140.8n 0
+ 142.25n 0
+ 142.3n 3.3
+ 146n 3.3
+ 146.05n 0
+ 146.75n 0
+ 146.8n 3.3
+ 147.5n 3.3
+ 147.55n 0
+ 150.5n 0
+ 150.55n 3.3
+ 152.75n 3.3
+ 152.8n 0
+ 155n 0
+ 155.05n 3.3
+ 155.75n 3.3
+ 155.8n 0
+ 157.25n 0
+ 157.3n 3.3
+ 158n 3.3
+ 158.05n 0
+ 159.5n 0
+ 159.55n 3.3
+ 161n 3.3
+ 161.05n 0
+ 161.75n 0
+ 161.8n 3.3
+ 163.25n 3.3
+ 163.3n 0
+ 164n 0
+ 164.05n 3.3
+ 164.75n 3.3
+ 164.8n 0
+ 165.5n 0
+ 165.55n 3.3
+ 167n 3.3
+ 167.05n 0
+ 167.75n 0
+ 167.8n 3.3
+ 170.75n 3.3
+ 170.8n 0
+ 171.5n 0
+ 171.55n 3.3
+ 173n 3.3
+ 173.05n 0
+ 175.25n 0
+ 175.3n 3.3
+ 176.75n 3.3
+ 176.8n 0
+ 177.5n 0
+ 177.55n 3.3
+ 178.25n 3.3
+ 178.3n 0
+ 179.75n 0
+ 179.8n 3.3
+ 180.5n 3.3
+ 180.55n 0
+ 181.25n 0
+ 181.3n 3.3
+ 183.5n 3.3
+ 183.55n 0
+ 184.25n 0
+ 184.3n 3.3
+ 186.5n 3.3
+ 186.55n 0
+ 188n 0
+ 188.05n 3.3
+ 189.5n 3.3
+ 189.55n 0
+ 191n 0
+ 191.05n 3.3
+ 191.75n 3.3
+ 191.8n 0
+ 192.5n 0
+ 192.55n 3.3
+ 193.25n 3.3
+ 193.3n 0
+ 194n 0
+ 194.05n 3.3
+ 194.75n 3.3
+ 194.8n 0
+ 195.5n 0
+ 204.5n 0 )

.include 'hspice.mod'
.subckt EX2_BUFFER in out vdd gnd
.include 'buffer.sp'
.ends EX2_BUFFER
Vdd vdd 0 DC 3.3
XDUT in_dig pad_sp vdd 0 EX2_BUFFER
Rload pad_sp 0 50
Cload pad_sp 0 2p

.probe tran V(in_dig) V(pad_sp) v(xdut.n4)
.tran 0.005n 204.5n
.end
