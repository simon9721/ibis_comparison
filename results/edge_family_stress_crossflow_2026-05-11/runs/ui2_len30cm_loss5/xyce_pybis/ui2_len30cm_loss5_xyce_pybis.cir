* ui2_len30cm_loss5 / xyce_pybis
* Inline PRBS7 V-source PWL stimulus
* 200 bits, UI=2.000 ns, tr/tf=200 ps
Vstim  in_dig  0  PWL(0.000000000e+00 0.0000
+ 2.000000000e-09  0.0000
+ 4.000000000e-09  0.0000
+ 6.000000000e-09  0.0000
+ 8.000000000e-09  0.0000
+ 1.000000000e-08  0.0000
+ 1.200000000e-08  0.0000
+ 1.400000000e-08  0.0000
+ 1.420000000e-08  3.3000
+ 1.600000000e-08  3.3000
+ 1.800000000e-08  3.3000
+ 2.000000000e-08  3.3000
+ 2.200000000e-08  3.3000
+ 2.400000000e-08  3.3000
+ 2.600000000e-08  3.3000
+ 2.620000000e-08  0.0000
+ 2.800000000e-08  0.0000
+ 2.820000000e-08  3.3000
+ 3.000000000e-08  3.3000
+ 3.200000000e-08  3.3000
+ 3.400000000e-08  3.3000
+ 3.600000000e-08  3.3000
+ 3.800000000e-08  3.3000
+ 3.820000000e-08  0.0000
+ 4.000000000e-08  0.0000
+ 4.200000000e-08  0.0000
+ 4.220000000e-08  3.3000
+ 4.400000000e-08  3.3000
+ 4.600000000e-08  3.3000
+ 4.800000000e-08  3.3000
+ 5.000000000e-08  3.3000
+ 5.020000000e-08  0.0000
+ 5.200000000e-08  0.0000
+ 5.220000000e-08  3.3000
+ 5.400000000e-08  3.3000
+ 5.420000000e-08  0.0000
+ 5.600000000e-08  0.0000
+ 5.620000000e-08  3.3000
+ 5.800000000e-08  3.3000
+ 6.000000000e-08  3.3000
+ 6.200000000e-08  3.3000
+ 6.220000000e-08  0.0000
+ 6.400000000e-08  0.0000
+ 6.600000000e-08  0.0000
+ 6.800000000e-08  0.0000
+ 7.000000000e-08  0.0000
+ 7.020000000e-08  3.3000
+ 7.200000000e-08  3.3000
+ 7.400000000e-08  3.3000
+ 7.420000000e-08  0.0000
+ 7.600000000e-08  0.0000
+ 7.620000000e-08  3.3000
+ 7.800000000e-08  3.3000
+ 8.000000000e-08  3.3000
+ 8.200000000e-08  3.3000
+ 8.220000000e-08  0.0000
+ 8.400000000e-08  0.0000
+ 8.420000000e-08  3.3000
+ 8.600000000e-08  3.3000
+ 8.620000000e-08  0.0000
+ 8.800000000e-08  0.0000
+ 9.000000000e-08  0.0000
+ 9.020000000e-08  3.3000
+ 9.200000000e-08  3.3000
+ 9.400000000e-08  3.3000
+ 9.420000000e-08  0.0000
+ 9.600000000e-08  0.0000
+ 9.800000000e-08  0.0000
+ 1.000000000e-07  0.0000
+ 1.002000000e-07  3.3000
+ 1.020000000e-07  3.3000
+ 1.022000000e-07  0.0000
+ 1.040000000e-07  0.0000
+ 1.042000000e-07  3.3000
+ 1.060000000e-07  3.3000
+ 1.062000000e-07  0.0000
+ 1.080000000e-07  0.0000
+ 1.082000000e-07  3.3000
+ 1.100000000e-07  3.3000
+ 1.120000000e-07  3.3000
+ 1.122000000e-07  0.0000
+ 1.140000000e-07  0.0000
+ 1.160000000e-07  0.0000
+ 1.180000000e-07  0.0000
+ 1.200000000e-07  0.0000
+ 1.220000000e-07  0.0000
+ 1.222000000e-07  3.3000
+ 1.240000000e-07  3.3000
+ 1.242000000e-07  0.0000
+ 1.260000000e-07  0.0000
+ 1.262000000e-07  3.3000
+ 1.280000000e-07  3.3000
+ 1.300000000e-07  3.3000
+ 1.320000000e-07  3.3000
+ 1.340000000e-07  3.3000
+ 1.342000000e-07  0.0000
+ 1.360000000e-07  0.0000
+ 1.380000000e-07  0.0000
+ 1.400000000e-07  0.0000
+ 1.402000000e-07  3.3000
+ 1.420000000e-07  3.3000
+ 1.440000000e-07  3.3000
+ 1.460000000e-07  3.3000
+ 1.462000000e-07  0.0000
+ 1.480000000e-07  0.0000
+ 1.482000000e-07  3.3000
+ 1.500000000e-07  3.3000
+ 1.520000000e-07  3.3000
+ 1.522000000e-07  0.0000
+ 1.540000000e-07  0.0000
+ 1.542000000e-07  3.3000
+ 1.560000000e-07  3.3000
+ 1.580000000e-07  3.3000
+ 1.582000000e-07  0.0000
+ 1.600000000e-07  0.0000
+ 1.620000000e-07  0.0000
+ 1.622000000e-07  3.3000
+ 1.640000000e-07  3.3000
+ 1.642000000e-07  0.0000
+ 1.660000000e-07  0.0000
+ 1.680000000e-07  0.0000
+ 1.682000000e-07  3.3000
+ 1.700000000e-07  3.3000
+ 1.702000000e-07  0.0000
+ 1.720000000e-07  0.0000
+ 1.722000000e-07  3.3000
+ 1.740000000e-07  3.3000
+ 1.742000000e-07  0.0000
+ 1.760000000e-07  0.0000
+ 1.780000000e-07  0.0000
+ 1.782000000e-07  3.3000
+ 1.800000000e-07  3.3000
+ 1.802000000e-07  0.0000
+ 1.820000000e-07  0.0000
+ 1.840000000e-07  0.0000
+ 1.860000000e-07  0.0000
+ 1.880000000e-07  0.0000
+ 1.882000000e-07  3.3000
+ 1.900000000e-07  3.3000
+ 1.902000000e-07  0.0000
+ 1.920000000e-07  0.0000
+ 1.940000000e-07  0.0000
+ 1.942000000e-07  3.3000
+ 1.960000000e-07  3.3000
+ 1.980000000e-07  3.3000
+ 2.000000000e-07  3.3000
+ 2.002000000e-07  0.0000
+ 2.020000000e-07  0.0000
+ 2.040000000e-07  0.0000
+ 2.042000000e-07  3.3000
+ 2.060000000e-07  3.3000
+ 2.062000000e-07  0.0000
+ 2.080000000e-07  0.0000
+ 2.082000000e-07  3.3000
+ 2.100000000e-07  3.3000
+ 2.120000000e-07  3.3000
+ 2.122000000e-07  0.0000
+ 2.140000000e-07  0.0000
+ 2.142000000e-07  3.3000
+ 2.160000000e-07  3.3000
+ 2.162000000e-07  0.0000
+ 2.180000000e-07  0.0000
+ 2.200000000e-07  0.0000
+ 2.220000000e-07  0.0000
+ 2.222000000e-07  3.3000
+ 2.240000000e-07  3.3000
+ 2.242000000e-07  0.0000
+ 2.260000000e-07  0.0000
+ 2.280000000e-07  0.0000
+ 2.300000000e-07  0.0000
+ 2.302000000e-07  3.3000
+ 2.320000000e-07  3.3000
+ 2.340000000e-07  3.3000
+ 2.342000000e-07  0.0000
+ 2.360000000e-07  0.0000
+ 2.380000000e-07  0.0000
+ 2.382000000e-07  3.3000
+ 2.400000000e-07  3.3000
+ 2.420000000e-07  3.3000
+ 2.422000000e-07  0.0000
+ 2.440000000e-07  0.0000
+ 2.442000000e-07  3.3000
+ 2.460000000e-07  3.3000
+ 2.462000000e-07  0.0000
+ 2.480000000e-07  0.0000
+ 2.482000000e-07  3.3000
+ 2.500000000e-07  3.3000
+ 2.502000000e-07  0.0000
+ 2.520000000e-07  0.0000
+ 2.522000000e-07  3.3000
+ 2.540000000e-07  3.3000
+ 2.542000000e-07  0.0000
+ 2.560000000e-07  0.0000
+ 2.580000000e-07  0.0000
+ 2.600000000e-07  0.0000
+ 2.620000000e-07  0.0000
+ 2.640000000e-07  0.0000
+ 2.660000000e-07  0.0000
+ 2.680000000e-07  0.0000
+ 2.682000000e-07  3.3000
+ 2.700000000e-07  3.3000
+ 2.720000000e-07  3.3000
+ 2.740000000e-07  3.3000
+ 2.760000000e-07  3.3000
+ 2.780000000e-07  3.3000
+ 2.800000000e-07  3.3000
+ 2.802000000e-07  0.0000
+ 2.820000000e-07  0.0000
+ 2.822000000e-07  3.3000
+ 2.840000000e-07  3.3000
+ 2.860000000e-07  3.3000
+ 2.880000000e-07  3.3000
+ 2.900000000e-07  3.3000
+ 2.920000000e-07  3.3000
+ 2.922000000e-07  0.0000
+ 2.940000000e-07  0.0000
+ 2.960000000e-07  0.0000
+ 2.962000000e-07  3.3000
+ 2.980000000e-07  3.3000
+ 3.000000000e-07  3.3000
+ 3.020000000e-07  3.3000
+ 3.040000000e-07  3.3000
+ 3.042000000e-07  0.0000
+ 3.060000000e-07  0.0000
+ 3.062000000e-07  3.3000
+ 3.080000000e-07  3.3000
+ 3.082000000e-07  0.0000
+ 3.100000000e-07  0.0000
+ 3.102000000e-07  3.3000
+ 3.120000000e-07  3.3000
+ 3.140000000e-07  3.3000
+ 3.160000000e-07  3.3000
+ 3.162000000e-07  0.0000
+ 3.180000000e-07  0.0000
+ 3.200000000e-07  0.0000
+ 3.220000000e-07  0.0000
+ 3.240000000e-07  0.0000
+ 3.242000000e-07  3.3000
+ 3.260000000e-07  3.3000
+ 3.280000000e-07  3.3000
+ 3.282000000e-07  0.0000
+ 3.300000000e-07  0.0000
+ 3.302000000e-07  3.3000
+ 3.320000000e-07  3.3000
+ 3.340000000e-07  3.3000
+ 3.360000000e-07  3.3000
+ 3.362000000e-07  0.0000
+ 3.380000000e-07  0.0000
+ 3.382000000e-07  3.3000
+ 3.400000000e-07  3.3000
+ 3.402000000e-07  0.0000
+ 3.420000000e-07  0.0000
+ 3.440000000e-07  0.0000
+ 3.442000000e-07  3.3000
+ 3.460000000e-07  3.3000
+ 3.480000000e-07  3.3000
+ 3.482000000e-07  0.0000
+ 3.500000000e-07  0.0000
+ 3.520000000e-07  0.0000
+ 3.540000000e-07  0.0000
+ 3.542000000e-07  3.3000
+ 3.560000000e-07  3.3000
+ 3.562000000e-07  0.0000
+ 3.580000000e-07  0.0000
+ 3.582000000e-07  3.3000
+ 3.600000000e-07  3.3000
+ 3.602000000e-07  0.0000
+ 3.620000000e-07  0.0000
+ 3.622000000e-07  3.3000
+ 3.640000000e-07  3.3000
+ 3.660000000e-07  3.3000
+ 3.662000000e-07  0.0000
+ 3.680000000e-07  0.0000
+ 3.700000000e-07  0.0000
+ 3.720000000e-07  0.0000
+ 3.740000000e-07  0.0000
+ 3.760000000e-07  0.0000
+ 3.762000000e-07  3.3000
+ 3.780000000e-07  3.3000
+ 3.782000000e-07  0.0000
+ 3.800000000e-07  0.0000
+ 3.802000000e-07  3.3000
+ 3.820000000e-07  3.3000
+ 3.840000000e-07  3.3000
+ 3.860000000e-07  3.3000
+ 3.880000000e-07  3.3000
+ 3.882000000e-07  0.0000
+ 3.900000000e-07  0.0000
+ 3.920000000e-07  0.0000
+ 3.940000000e-07  0.0000
+ 3.942000000e-07  3.3000
+ 3.960000000e-07  3.3000
+ 3.980000000e-07  3.3000
+ 4.000000000e-07  3.3000)
Ven   en_sig  0  DC 3.3
Vdd   vdd     0  DC 3.3

.include '../../../../../xyce_pybis/driver_OutputInput_Typical_xyce_relaxed92_edge15_tailflat4p2.sub'
XDRV  pad  in_dig  en_sig  vdd  0  driver_OutputInput_Typical
RCH_TX  pad tx_out 1u
* Generated 30-section RLGC ladder for xyce
* length_scale=3, loss_scale=5
* nominal one-way delay=2.076 ns
RCH1   tx_out   s1a      0.25
LCH1   s1a      s1b      3.460000000e-09
CCH1   s1b      0        1.384000000e-12
RGCH1   s1b      0        200000
RCH2   s1b      s2a      0.25
LCH2   s2a      s2b      3.460000000e-09
CCH2   s2b      0        1.384000000e-12
RGCH2   s2b      0        200000
RCH3   s2b      s3a      0.25
LCH3   s3a      s3b      3.460000000e-09
CCH3   s3b      0        1.384000000e-12
RGCH3   s3b      0        200000
RCH4   s3b      s4a      0.25
LCH4   s4a      s4b      3.460000000e-09
CCH4   s4b      0        1.384000000e-12
RGCH4   s4b      0        200000
RCH5   s4b      s5a      0.25
LCH5   s5a      s5b      3.460000000e-09
CCH5   s5b      0        1.384000000e-12
RGCH5   s5b      0        200000
RCH6   s5b      s6a      0.25
LCH6   s6a      s6b      3.460000000e-09
CCH6   s6b      0        1.384000000e-12
RGCH6   s6b      0        200000
RCH7   s6b      s7a      0.25
LCH7   s7a      s7b      3.460000000e-09
CCH7   s7b      0        1.384000000e-12
RGCH7   s7b      0        200000
RCH8   s7b      s8a      0.25
LCH8   s8a      s8b      3.460000000e-09
CCH8   s8b      0        1.384000000e-12
RGCH8   s8b      0        200000
RCH9   s8b      s9a      0.25
LCH9   s9a      s9b      3.460000000e-09
CCH9   s9b      0        1.384000000e-12
RGCH9   s9b      0        200000
RCH10  s9b      s10a     0.25
LCH10  s10a     s10b     3.460000000e-09
CCH10  s10b     0        1.384000000e-12
RGCH10  s10b     0        200000
RCH11  s10b     s11a     0.25
LCH11  s11a     s11b     3.460000000e-09
CCH11  s11b     0        1.384000000e-12
RGCH11  s11b     0        200000
RCH12  s11b     s12a     0.25
LCH12  s12a     s12b     3.460000000e-09
CCH12  s12b     0        1.384000000e-12
RGCH12  s12b     0        200000
RCH13  s12b     s13a     0.25
LCH13  s13a     s13b     3.460000000e-09
CCH13  s13b     0        1.384000000e-12
RGCH13  s13b     0        200000
RCH14  s13b     s14a     0.25
LCH14  s14a     s14b     3.460000000e-09
CCH14  s14b     0        1.384000000e-12
RGCH14  s14b     0        200000
RCH15  s14b     s15a     0.25
LCH15  s15a     s15b     3.460000000e-09
CCH15  s15b     0        1.384000000e-12
RGCH15  s15b     0        200000
RCH16  s15b     s16a     0.25
LCH16  s16a     s16b     3.460000000e-09
CCH16  s16b     0        1.384000000e-12
RGCH16  s16b     0        200000
RCH17  s16b     s17a     0.25
LCH17  s17a     s17b     3.460000000e-09
CCH17  s17b     0        1.384000000e-12
RGCH17  s17b     0        200000
RCH18  s17b     s18a     0.25
LCH18  s18a     s18b     3.460000000e-09
CCH18  s18b     0        1.384000000e-12
RGCH18  s18b     0        200000
RCH19  s18b     s19a     0.25
LCH19  s19a     s19b     3.460000000e-09
CCH19  s19b     0        1.384000000e-12
RGCH19  s19b     0        200000
RCH20  s19b     s20a     0.25
LCH20  s20a     s20b     3.460000000e-09
CCH20  s20b     0        1.384000000e-12
RGCH20  s20b     0        200000
RCH21  s20b     s21a     0.25
LCH21  s21a     s21b     3.460000000e-09
CCH21  s21b     0        1.384000000e-12
RGCH21  s21b     0        200000
RCH22  s21b     s22a     0.25
LCH22  s22a     s22b     3.460000000e-09
CCH22  s22b     0        1.384000000e-12
RGCH22  s22b     0        200000
RCH23  s22b     s23a     0.25
LCH23  s23a     s23b     3.460000000e-09
CCH23  s23b     0        1.384000000e-12
RGCH23  s23b     0        200000
RCH24  s23b     s24a     0.25
LCH24  s24a     s24b     3.460000000e-09
CCH24  s24b     0        1.384000000e-12
RGCH24  s24b     0        200000
RCH25  s24b     s25a     0.25
LCH25  s25a     s25b     3.460000000e-09
CCH25  s25b     0        1.384000000e-12
RGCH25  s25b     0        200000
RCH26  s25b     s26a     0.25
LCH26  s26a     s26b     3.460000000e-09
CCH26  s26b     0        1.384000000e-12
RGCH26  s26b     0        200000
RCH27  s26b     s27a     0.25
LCH27  s27a     s27b     3.460000000e-09
CCH27  s27b     0        1.384000000e-12
RGCH27  s27b     0        200000
RCH28  s27b     s28a     0.25
LCH28  s28a     s28b     3.460000000e-09
CCH28  s28b     0        1.384000000e-12
RGCH28  s28b     0        200000
RCH29  s28b     s29a     0.25
LCH29  s29a     s29b     3.460000000e-09
CCH29  s29b     0        1.384000000e-12
RGCH29  s29b     0        200000
RCH30  s29b     s30a     0.25
LCH30  s30a     n10b     3.460000000e-09
CCH30  n10b     0        1.384000000e-12
RGCH30  n10b     0        200000
RTERM   n10b 0 50

.ic V(pad)=0 V(tx_out)=0 V(n10b)=0 V(XDRV:Ku)=0 V(XDRV:Kd)=1 V(XDRV:NX)=0 V(XDRV:N6)=0 V(XDRV:N8)=0
.options timeint method=trap maxord=1 erroption=1 delmax=20p nlmin=3 nlmax=8 timestepsreversal=1
.options output initial_interval=10p
.tran 1.000000000e-11 4.000000000e-07 uic
.print tran format=csv time V(in_dig) V(pad) V(tx_out) V(n10b) V(XDRV:Ku) V(XDRV:Kd) V(XDRV:NX)
.end
