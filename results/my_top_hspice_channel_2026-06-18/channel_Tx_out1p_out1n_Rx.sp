* Net list generated by Topology Workbench, Cadence Design Systems Inc.

* Simulator: SPDSIM (-noramp)
* Simulator Path: C:\Cadence\Sigrity2025.1\\tools\bin\SPDsimCon.exe

* Add global .option and .include commands here.
* They'll be used for time domain characterization.
*.option delmax=1p

.option post=2 probe

.inc 'C:\Program Files\Cadence\SPB_24.1\share\topxp\standard_step.sp'
.inc 'channel_Tx_out1p_out1n_Rx_ibis.sp'
.inc 'S1.sp'

X1 n1 n2 pwr1 gnd in
+ Tx_ABC_Serdes

X2 n1 gnd n2 n3 gnd n4
+ S1_sparams_4port_bnp

X3 n3 n4 pwr2 gnd rxnode
+ Rx_ABC_Serdes

Xstim in gnd standard_step tdel = 0n

.tran 2.000000p 30.000000n

.print V(in, gnd)		$ view Tx waveform
.print V(rxnode, gnd)		$ view Rx waveform
.print V(n3, gnd)		$ view Rx waveform
.print V(n4, gnd)		$ view Rx waveform
.probe tran V(in,gnd) V(rxnode,gnd) V(n1,gnd) V(n2,gnd) V(n3,gnd) V(n4,gnd) V(n3,n4)

.end
