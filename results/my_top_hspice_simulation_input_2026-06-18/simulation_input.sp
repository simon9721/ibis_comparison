* Net list generated by Topology Workbench.

.inc 'simulation_ibis_definition.sp'

.option post=2 probe

X1 n1 n2 n3 gnd Tx_ABC_Serdes
X2 n1 n2 n3 gnd Tx_ABC_Serdes_Test_Fixture

.tran 2.000000p 2.000000n
.print V(n1, gnd)
.print V(n2, gnd)
.print V(n1, n2)
.probe tran V(n1, gnd) V(n2, gnd) V(n1, n2)

* Add global .option and .include commands here.
* They'll be used for time domain characterization.
*.option delmax=1p

.end
