* EQUIVALENT CIRCUIT FOR VECTOR FITTED S-MATRIX
* Created using scikit-rf vectorFitting.py
*
.SUBCKT s_equivalent p1 p2
*
* Port network for port 1
V1 p1 s1 0
R1 s1 0 50.0
Gr1_1_1 0 s1 x1_a1 0 0.0
Gr2_1_1 0 s1 x2_a1 0 0.0
Gr3_1_1 0 s1 x3_a1 0 0.0
Gr1_1_2 0 s1 x1_a2 0 0.0
Gr2_1_2 0 s1 x2_a2 0 0.0
Gr3_1_2 0 s1 x3_a2 0 0.0
*
* State networks driven by port 1
Cx1_a1 x1_a1 0 1.0
Gx1_a1 0 x1_a1 p1 0 0.07071067811865475
Fx1_a1 0 x1_a1 V1 3.5355339059327378
Rp1_a1 0 x1_a1 7.46909775603485e-12
Cx2_a1 x2_a1 0 1.0
Gx2_a1 0 x2_a1 p1 0 0.07071067811865475
Fx2_a1 0 x2_a1 V1 3.5355339059327378
Rp2_a1 0 x2_a1 9.426295727692216e-11
Cx3_a1 x3_a1 0 1.0
Gx3_a1 0 x3_a1 p1 0 0.07071067811865475
Fx3_a1 0 x3_a1 V1 3.5355339059327378
Rp3_a1 0 x3_a1 2.4702366979665987e-09
*
* Port network for port 2
V2 p2 s2 0
R2 s2 0 50.0
Gd2_1 0 s2 p1 0 0.2000000000000003
Fd2_1 0 s2 V1 10.000000000000016
Gr1_2_1 0 s2 x1_a1 0 -0.0005021133164545831
Gr2_2_1 0 s2 x2_a1 0 1.2807720986305033e-05
Gr3_2_1 0 s2 x3_a1 0 -3.4939557571597486e-06
Gr1_2_2 0 s2 x1_a2 0 0.0
Gr2_2_2 0 s2 x2_a2 0 0.0
Gr3_2_2 0 s2 x3_a2 0 0.0
*
* State networks driven by port 2
Cx1_a2 x1_a2 0 1.0
Gx1_a2 0 x1_a2 p2 0 0.07071067811865475
Fx1_a2 0 x1_a2 V2 3.5355339059327378
Rp1_a2 0 x1_a2 7.46909775603485e-12
Cx2_a2 x2_a2 0 1.0
Gx2_a2 0 x2_a2 p2 0 0.07071067811865475
Fx2_a2 0 x2_a2 V2 3.5355339059327378
Rp2_a2 0 x2_a2 9.426295727692216e-11
Cx3_a2 x3_a2 0 1.0
Gx3_a2 0 x3_a2 p2 0 0.07071067811865475
Fx3_a2 0 x3_a2 V2 3.5355339059327378
Rp3_a2 0 x3_a2 2.4702366979665987e-09
.ENDS s_equivalent
