* EQUIVALENT CIRCUIT FOR VECTOR FITTED S-MATRIX
* Created using scikit-rf vectorFitting.py
*
.SUBCKT s_equivalent p1 p2
*
* Port network for port 1
V1 p1 s1 0
R1 s1 0 50.0
Gd1_1 0 s1 p1 0 -3.178682537149544e-05
Fd1_1 0 s1 V1 -0.0015893412685747718
Gr1_re_1_1 0 s1 x1_re_a1 0 1852540759.7679703
Gr1_im_1_1 0 s1 x1_im_a1 0 2585047862.742821
Gr2_re_1_1 0 s1 x2_re_a1 0 6518662635.19754
Gr2_im_1_1 0 s1 x2_im_a1 0 1183043099.0260398
Gr3_re_1_1 0 s1 x3_re_a1 0 -1343633723.6543894
Gr3_im_1_1 0 s1 x3_im_a1 0 -37464754.16050016
Gr4_re_1_1 0 s1 x4_re_a1 0 14834392925.055614
Gr4_im_1_1 0 s1 x4_im_a1 0 -8640613804.021801
Gr5_re_1_1 0 s1 x5_re_a1 0 -11783143025.02439
Gr5_im_1_1 0 s1 x5_im_a1 0 -3732884720.7845817
Gr6_re_1_1 0 s1 x6_re_a1 0 281811.09215058706
Gr6_im_1_1 0 s1 x6_im_a1 0 -960800.572213157
Gr7_re_1_1 0 s1 x7_re_a1 0 5371798192.722408
Gr7_im_1_1 0 s1 x7_im_a1 0 5035826872.118395
Gr8_re_1_1 0 s1 x8_re_a1 0 1432470219.8977225
Gr8_im_1_1 0 s1 x8_im_a1 0 -6852712522.789384
Gr9_re_1_1 0 s1 x9_re_a1 0 7576515927.266854
Gr9_im_1_1 0 s1 x9_im_a1 0 -2286511775.3481207
Gr10_re_1_1 0 s1 x10_re_a1 0 -23062454426.254185
Gr10_im_1_1 0 s1 x10_im_a1 0 -16057283661.49456
Gr11_re_1_1 0 s1 x11_re_a1 0 1388738394.3705852
Gr11_im_1_1 0 s1 x11_im_a1 0 8919851006.848782
Gr12_re_1_1 0 s1 x12_re_a1 0 -1585633223.1635752
Gr12_im_1_1 0 s1 x12_im_a1 0 -5571165248.935732
Gr13_re_1_1 0 s1 x13_re_a1 0 -138527387.52053764
Gr13_im_1_1 0 s1 x13_im_a1 0 1573134237.656471
Gr14_re_1_1 0 s1 x14_re_a1 0 -3682602924.0923624
Gr14_im_1_1 0 s1 x14_im_a1 0 455350659.8083444
Gr15_re_1_1 0 s1 x15_re_a1 0 -8538911.129840022
Gr15_im_1_1 0 s1 x15_im_a1 0 -7212963.630728868
Gr16_re_1_1 0 s1 x16_re_a1 0 2413335960.758775
Gr16_im_1_1 0 s1 x16_im_a1 0 -1251455985.449822
Gr17_re_1_1 0 s1 x17_re_a1 0 -10337667741.258186
Gr17_im_1_1 0 s1 x17_im_a1 0 266269535.24171865
Gr18_1_1 0 s1 x18_a1 0 -33633757944.04182
Gr19_re_1_1 0 s1 x19_re_a1 0 -2922353298.7567997
Gr19_im_1_1 0 s1 x19_im_a1 0 11859496207.893648
Gr20_re_1_1 0 s1 x20_re_a1 0 6715661532.901646
Gr20_im_1_1 0 s1 x20_im_a1 0 -1606267047.859442
Gr21_re_1_1 0 s1 x21_re_a1 0 -3195791090.471953
Gr21_im_1_1 0 s1 x21_im_a1 0 6243079888.066761
Gr22_re_1_1 0 s1 x22_re_a1 0 1004398565.2805856
Gr22_im_1_1 0 s1 x22_im_a1 0 -1863648693.670229
Gr23_re_1_1 0 s1 x23_re_a1 0 3798822537.1120496
Gr23_im_1_1 0 s1 x23_im_a1 0 -36875640451.1137
Gr24_1_1 0 s1 x24_a1 0 1527099394.5018985
Gr25_1_1 0 s1 x25_a1 0 -139538164.73992434
Gr26_re_1_1 0 s1 x26_re_a1 0 -511964170.78215814
Gr26_im_1_1 0 s1 x26_im_a1 0 316207093.0791163
Gr27_re_1_1 0 s1 x27_re_a1 0 -91098475.42021807
Gr27_im_1_1 0 s1 x27_im_a1 0 239226189.0667143
Gr28_re_1_1 0 s1 x28_re_a1 0 845331986.2217361
Gr28_im_1_1 0 s1 x28_im_a1 0 1322290259.2774374
Gr29_re_1_1 0 s1 x29_re_a1 0 644197459.2941269
Gr29_im_1_1 0 s1 x29_im_a1 0 1476056455.8141518
Gr30_re_1_1 0 s1 x30_re_a1 0 1713710816.4643896
Gr30_im_1_1 0 s1 x30_im_a1 0 935278535.8766919
Gr31_re_1_1 0 s1 x31_re_a1 0 -127428459.79579668
Gr31_im_1_1 0 s1 x31_im_a1 0 229928093.64444244
Gr32_re_1_1 0 s1 x32_re_a1 0 2417956948.3601947
Gr32_im_1_1 0 s1 x32_im_a1 0 207405900.47318512
Gr33_re_1_1 0 s1 x33_re_a1 0 -372148686.5977608
Gr33_im_1_1 0 s1 x33_im_a1 0 11842341482.806992
Gr34_re_1_1 0 s1 x34_re_a1 0 5865082748.734932
Gr34_im_1_1 0 s1 x34_im_a1 0 -2165455026.7245173
Gd1_2 0 s1 p2 0 3.59653487733702e-05
Fd1_2 0 s1 V2 0.0017982674386685102
Gr1_re_1_2 0 s1 x1_re_a2 0 223438189.78963324
Gr1_im_1_2 0 s1 x1_im_a2 0 -519179112.8236982
Gr2_re_1_2 0 s1 x2_re_a2 0 417211192.06508994
Gr2_im_1_2 0 s1 x2_im_a2 0 -161297820.53815496
Gr3_re_1_2 0 s1 x3_re_a2 0 -361779751.0178591
Gr3_im_1_2 0 s1 x3_im_a2 0 614291060.898995
Gr4_re_1_2 0 s1 x4_re_a2 0 181057860.92124504
Gr4_im_1_2 0 s1 x4_im_a2 0 -104397579.05441415
Gr5_re_1_2 0 s1 x5_re_a2 0 45208105.578677215
Gr5_im_1_2 0 s1 x5_im_a2 0 -424210441.92445153
Gr6_re_1_2 0 s1 x6_re_a2 0 -65965.18828502517
Gr6_im_1_2 0 s1 x6_im_a2 0 261286.29107942779
Gr7_re_1_2 0 s1 x7_re_a2 0 76823551.56566447
Gr7_im_1_2 0 s1 x7_im_a2 0 -170031376.25517935
Gr8_re_1_2 0 s1 x8_re_a2 0 161440744.83554003
Gr8_im_1_2 0 s1 x8_im_a2 0 -334578783.80517167
Gr9_re_1_2 0 s1 x9_re_a2 0 -48419789.808773234
Gr9_im_1_2 0 s1 x9_im_a2 0 -240767859.3341526
Gr10_re_1_2 0 s1 x10_re_a2 0 -380975645.8747178
Gr10_im_1_2 0 s1 x10_im_a2 0 -760378444.2086036
Gr11_re_1_2 0 s1 x11_re_a2 0 -132654618.42487146
Gr11_im_1_2 0 s1 x11_im_a2 0 -149241751.13947612
Gr12_re_1_2 0 s1 x12_re_a2 0 -117599471.4428447
Gr12_im_1_2 0 s1 x12_im_a2 0 -379067100.44269234
Gr13_re_1_2 0 s1 x13_re_a2 0 36059528.25130293
Gr13_im_1_2 0 s1 x13_im_a2 0 -109801705.29614344
Gr14_re_1_2 0 s1 x14_re_a2 0 -123663756.8480668
Gr14_im_1_2 0 s1 x14_im_a2 0 -262055536.6915486
Gr15_re_1_2 0 s1 x15_re_a2 0 -5005734.193126144
Gr15_im_1_2 0 s1 x15_im_a2 0 -5128557.049193426
Gr16_re_1_2 0 s1 x16_re_a2 0 -18577747.803327914
Gr16_im_1_2 0 s1 x16_im_a2 0 -273037023.4386755
Gr17_re_1_2 0 s1 x17_re_a2 0 -97229621.11777085
Gr17_im_1_2 0 s1 x17_im_a2 0 -353505816.8814588
Gr18_1_2 0 s1 x18_a2 0 53176530302.4214
Gr19_re_1_2 0 s1 x19_re_a2 0 1359993410.7429056
Gr19_im_1_2 0 s1 x19_im_a2 0 -555398817.437618
Gr20_re_1_2 0 s1 x20_re_a2 0 -418853018.0934504
Gr20_im_1_2 0 s1 x20_im_a2 0 756094005.1136236
Gr21_re_1_2 0 s1 x21_re_a2 0 -7996383955.464466
Gr21_im_1_2 0 s1 x21_im_a2 0 -5119948379.9781
Gr22_re_1_2 0 s1 x22_re_a2 0 192221558.7597388
Gr22_im_1_2 0 s1 x22_im_a2 0 -68452696.76539694
Gr23_re_1_2 0 s1 x23_re_a2 0 -19977694018.99995
Gr23_im_1_2 0 s1 x23_im_a2 0 25325317345.97836
Gr24_1_2 0 s1 x24_a2 0 52192006.9156917
Gr25_1_2 0 s1 x25_a2 0 3774635.104709317
Gr26_re_1_2 0 s1 x26_re_a2 0 -38915623.421676934
Gr26_im_1_2 0 s1 x26_im_a2 0 34041166.24409855
Gr27_re_1_2 0 s1 x27_re_a2 0 -15228105.587332934
Gr27_im_1_2 0 s1 x27_im_a2 0 23245629.501957
Gr28_re_1_2 0 s1 x28_re_a2 0 101365957.41106713
Gr28_im_1_2 0 s1 x28_im_a2 0 46516779.64012195
Gr29_re_1_2 0 s1 x29_re_a2 0 -4250763.454227527
Gr29_im_1_2 0 s1 x29_im_a2 0 29258481.714737903
Gr30_re_1_2 0 s1 x30_re_a2 0 43577600.77037578
Gr30_im_1_2 0 s1 x30_im_a2 0 124467289.37662895
Gr31_re_1_2 0 s1 x31_re_a2 0 11917688.747280763
Gr31_im_1_2 0 s1 x31_im_a2 0 -49603089.879198514
Gr32_re_1_2 0 s1 x32_re_a2 0 147045292.77357838
Gr32_im_1_2 0 s1 x32_im_a2 0 200635802.0474872
Gr33_re_1_2 0 s1 x33_re_a2 0 1032984319.4714003
Gr33_im_1_2 0 s1 x33_im_a2 0 -73129203.05212615
Gr34_re_1_2 0 s1 x34_re_a2 0 27280309.204685636
Gr34_im_1_2 0 s1 x34_im_a2 0 -146519598.59979618
*
* State networks driven by port 1
Cx1_re_a1 x1_re_a1 0 1.0
Gx1_re_a1 0 x1_re_a1 p1 0 0.1414213562373095
Fx1_re_a1 0 x1_re_a1 V1 7.0710678118654755
Rp1_re_re_a1 0 x1_re_a1 3.516954575863237e-10
Gp1_re_im_a1 0 x1_re_a1 x1_im_a1 0 325797905716.9008
Cx1_im_a1 x1_im_a1 0 1.0
Gp1_im_re_a1 0 x1_im_a1 x1_re_a1 0 -325797905716.9008
Rp1_im_im_a1 0 x1_im_a1 3.516954575863237e-10
Cx2_re_a1 x2_re_a1 0 1.0
Gx2_re_a1 0 x2_re_a1 p1 0 0.1414213562373095
Fx2_re_a1 0 x2_re_a1 V1 7.0710678118654755
Rp2_re_re_a1 0 x2_re_a1 1.0416449466671259e-10
Gp2_re_im_a1 0 x2_re_a1 x2_im_a1 0 307667775748.4361
Cx2_im_a1 x2_im_a1 0 1.0
Gp2_im_re_a1 0 x2_im_a1 x2_re_a1 0 -307667775748.4361
Rp2_im_im_a1 0 x2_im_a1 1.0416449466671259e-10
Cx3_re_a1 x3_re_a1 0 1.0
Gx3_re_a1 0 x3_re_a1 p1 0 0.1414213562373095
Fx3_re_a1 0 x3_re_a1 V1 7.0710678118654755
Rp3_re_re_a1 0 x3_re_a1 1.1947047674594806e-10
Gp3_re_im_a1 0 x3_re_a1 x3_im_a1 0 297169406395.5486
Cx3_im_a1 x3_im_a1 0 1.0
Gp3_im_re_a1 0 x3_im_a1 x3_re_a1 0 -297169406395.5486
Rp3_im_im_a1 0 x3_im_a1 1.1947047674594806e-10
Cx4_re_a1 x4_re_a1 0 1.0
Gx4_re_a1 0 x4_re_a1 p1 0 0.1414213562373095
Fx4_re_a1 0 x4_re_a1 V1 7.0710678118654755
Rp4_re_re_a1 0 x4_re_a1 7.419159539578664e-11
Gp4_re_im_a1 0 x4_re_a1 x4_im_a1 0 286664634627.3183
Cx4_im_a1 x4_im_a1 0 1.0
Gp4_im_re_a1 0 x4_im_a1 x4_re_a1 0 -286664634627.3183
Rp4_im_im_a1 0 x4_im_a1 7.419159539578664e-11
Cx5_re_a1 x5_re_a1 0 1.0
Gx5_re_a1 0 x5_re_a1 p1 0 0.1414213562373095
Fx5_re_a1 0 x5_re_a1 V1 7.0710678118654755
Rp5_re_re_a1 0 x5_re_a1 8.691821820452219e-11
Gp5_re_im_a1 0 x5_re_a1 x5_im_a1 0 276066370424.8892
Cx5_im_a1 x5_im_a1 0 1.0
Gp5_im_re_a1 0 x5_im_a1 x5_re_a1 0 -276066370424.8892
Rp5_im_im_a1 0 x5_im_a1 8.691821820452219e-11
Cx6_re_a1 x6_re_a1 0 1.0
Gx6_re_a1 0 x6_re_a1 p1 0 0.1414213562373095
Fx6_re_a1 0 x6_re_a1 V1 7.0710678118654755
Rp6_re_re_a1 0 x6_re_a1 3.634721588276957e-09
Gp6_re_im_a1 0 x6_re_a1 x6_im_a1 0 262620842188.22052
Cx6_im_a1 x6_im_a1 0 1.0
Gp6_im_re_a1 0 x6_im_a1 x6_re_a1 0 -262620842188.22052
Rp6_im_im_a1 0 x6_im_a1 3.634721588276957e-09
Cx7_re_a1 x7_re_a1 0 1.0
Gx7_re_a1 0 x7_re_a1 p1 0 0.1414213562373095
Fx7_re_a1 0 x7_re_a1 V1 7.0710678118654755
Rp7_re_re_a1 0 x7_re_a1 1.0557552299979523e-10
Gp7_re_im_a1 0 x7_re_a1 x7_im_a1 0 261824227412.7352
Cx7_im_a1 x7_im_a1 0 1.0
Gp7_im_re_a1 0 x7_im_a1 x7_re_a1 0 -261824227412.7352
Rp7_im_im_a1 0 x7_im_a1 1.0557552299979523e-10
Cx8_re_a1 x8_re_a1 0 1.0
Gx8_re_a1 0 x8_re_a1 p1 0 0.1414213562373095
Fx8_re_a1 0 x8_re_a1 V1 7.0710678118654755
Rp8_re_re_a1 0 x8_re_a1 9.178308757909468e-11
Gp8_re_im_a1 0 x8_re_a1 x8_im_a1 0 251179700478.26138
Cx8_im_a1 x8_im_a1 0 1.0
Gp8_im_re_a1 0 x8_im_a1 x8_re_a1 0 -251179700478.26138
Rp8_im_im_a1 0 x8_im_a1 9.178308757909468e-11
Cx9_re_a1 x9_re_a1 0 1.0
Gx9_re_a1 0 x9_re_a1 p1 0 0.1414213562373095
Fx9_re_a1 0 x9_re_a1 V1 7.0710678118654755
Rp9_re_re_a1 0 x9_re_a1 1.0259453872405931e-10
Gp9_re_im_a1 0 x9_re_a1 x9_im_a1 0 242920287375.44836
Cx9_im_a1 x9_im_a1 0 1.0
Gp9_im_re_a1 0 x9_im_a1 x9_re_a1 0 -242920287375.44836
Rp9_im_im_a1 0 x9_im_a1 1.0259453872405931e-10
Cx10_re_a1 x10_re_a1 0 1.0
Gx10_re_a1 0 x10_re_a1 p1 0 0.1414213562373095
Fx10_re_a1 0 x10_re_a1 V1 7.0710678118654755
Rp10_re_re_a1 0 x10_re_a1 6.264244406931637e-11
Gp10_re_im_a1 0 x10_re_a1 x10_im_a1 0 231465146633.18985
Cx10_im_a1 x10_im_a1 0 1.0
Gp10_im_re_a1 0 x10_im_a1 x10_re_a1 0 -231465146633.18985
Rp10_im_im_a1 0 x10_im_a1 6.264244406931637e-11
Cx11_re_a1 x11_re_a1 0 1.0
Gx11_re_a1 0 x11_re_a1 p1 0 0.1414213562373095
Fx11_re_a1 0 x11_re_a1 V1 7.0710678118654755
Rp11_re_re_a1 0 x11_re_a1 1.0672326265370034e-10
Gp11_re_im_a1 0 x11_re_a1 x11_im_a1 0 219100062156.56302
Cx11_im_a1 x11_im_a1 0 1.0
Gp11_im_re_a1 0 x11_im_a1 x11_re_a1 0 -219100062156.56302
Rp11_im_im_a1 0 x11_im_a1 1.0672326265370034e-10
Cx12_re_a1 x12_re_a1 0 1.0
Gx12_re_a1 0 x12_re_a1 p1 0 0.1414213562373095
Fx12_re_a1 0 x12_re_a1 V1 7.0710678118654755
Rp12_re_re_a1 0 x12_re_a1 9.162057604637434e-11
Gp12_re_im_a1 0 x12_re_a1 x12_im_a1 0 207374196420.588
Cx12_im_a1 x12_im_a1 0 1.0
Gp12_im_re_a1 0 x12_im_a1 x12_re_a1 0 -207374196420.588
Rp12_im_im_a1 0 x12_im_a1 9.162057604637434e-11
Cx13_re_a1 x13_re_a1 0 1.0
Gx13_re_a1 0 x13_re_a1 p1 0 0.1414213562373095
Fx13_re_a1 0 x13_re_a1 V1 7.0710678118654755
Rp13_re_re_a1 0 x13_re_a1 1.7288899805088173e-10
Gp13_re_im_a1 0 x13_re_a1 x13_im_a1 0 198534054813.4038
Cx13_im_a1 x13_im_a1 0 1.0
Gp13_im_re_a1 0 x13_im_a1 x13_re_a1 0 -198534054813.4038
Rp13_im_im_a1 0 x13_im_a1 1.7288899805088173e-10
Cx14_re_a1 x14_re_a1 0 1.0
Gx14_re_a1 0 x14_re_a1 p1 0 0.1414213562373095
Fx14_re_a1 0 x14_re_a1 V1 7.0710678118654755
Rp14_re_re_a1 0 x14_re_a1 1.352324940520366e-10
Gp14_re_im_a1 0 x14_re_a1 x14_im_a1 0 193230124137.5904
Cx14_im_a1 x14_im_a1 0 1.0
Gp14_im_re_a1 0 x14_im_a1 x14_re_a1 0 -193230124137.5904
Rp14_im_im_a1 0 x14_im_a1 1.352324940520366e-10
Cx15_re_a1 x15_re_a1 0 1.0
Gx15_re_a1 0 x15_re_a1 p1 0 0.1414213562373095
Fx15_re_a1 0 x15_re_a1 V1 7.0710678118654755
Rp15_re_re_a1 0 x15_re_a1 4.93306865845889e-10
Gp15_re_im_a1 0 x15_re_a1 x15_im_a1 0 188469964612.31436
Cx15_im_a1 x15_im_a1 0 1.0
Gp15_im_re_a1 0 x15_im_a1 x15_re_a1 0 -188469964612.31436
Rp15_im_im_a1 0 x15_im_a1 4.93306865845889e-10
Cx16_re_a1 x16_re_a1 0 1.0
Gx16_re_a1 0 x16_re_a1 p1 0 0.1414213562373095
Fx16_re_a1 0 x16_re_a1 V1 7.0710678118654755
Rp16_re_re_a1 0 x16_re_a1 1.2598956894826076e-10
Gp16_re_im_a1 0 x16_re_a1 x16_im_a1 0 182741455724.2421
Cx16_im_a1 x16_im_a1 0 1.0
Gp16_im_re_a1 0 x16_im_a1 x16_re_a1 0 -182741455724.2421
Rp16_im_im_a1 0 x16_im_a1 1.2598956894826076e-10
Cx17_re_a1 x17_re_a1 0 1.0
Gx17_re_a1 0 x17_re_a1 p1 0 0.1414213562373095
Fx17_re_a1 0 x17_re_a1 V1 7.0710678118654755
Rp17_re_re_a1 0 x17_re_a1 1.1073834394083287e-10
Gp17_re_im_a1 0 x17_re_a1 x17_im_a1 0 174314910045.04767
Cx17_im_a1 x17_im_a1 0 1.0
Gp17_im_re_a1 0 x17_im_a1 x17_re_a1 0 -174314910045.04767
Rp17_im_im_a1 0 x17_im_a1 1.1073834394083287e-10
Cx18_a1 x18_a1 0 1.0
Gx18_a1 0 x18_a1 p1 0 0.07071067811865475
Fx18_a1 0 x18_a1 V1 3.5355339059327378
Rp18_a1 0 x18_a1 1.7929961225020097e-11
Cx19_re_a1 x19_re_a1 0 1.0
Gx19_re_a1 0 x19_re_a1 p1 0 0.1414213562373095
Fx19_re_a1 0 x19_re_a1 V1 7.0710678118654755
Rp19_re_re_a1 0 x19_re_a1 1.1570829433911795e-10
Gp19_re_im_a1 0 x19_re_a1 x19_im_a1 0 161358251608.1025
Cx19_im_a1 x19_im_a1 0 1.0
Gp19_im_re_a1 0 x19_im_a1 x19_re_a1 0 -161358251608.1025
Rp19_im_im_a1 0 x19_im_a1 1.1570829433911795e-10
Cx20_re_a1 x20_re_a1 0 1.0
Gx20_re_a1 0 x20_re_a1 p1 0 0.1414213562373095
Fx20_re_a1 0 x20_re_a1 V1 7.0710678118654755
Rp20_re_re_a1 0 x20_re_a1 1.3008612516807973e-10
Gp20_re_im_a1 0 x20_re_a1 x20_im_a1 0 154920423349.12296
Cx20_im_a1 x20_im_a1 0 1.0
Gp20_im_re_a1 0 x20_im_a1 x20_re_a1 0 -154920423349.12296
Rp20_im_im_a1 0 x20_im_a1 1.3008612516807973e-10
Cx21_re_a1 x21_re_a1 0 1.0
Gx21_re_a1 0 x21_re_a1 p1 0 0.1414213562373095
Fx21_re_a1 0 x21_re_a1 V1 7.0710678118654755
Rp21_re_re_a1 0 x21_re_a1 5.364987040024318e-11
Gp21_re_im_a1 0 x21_re_a1 x21_im_a1 0 144651700109.96158
Cx21_im_a1 x21_im_a1 0 1.0
Gp21_im_re_a1 0 x21_im_a1 x21_re_a1 0 -144651700109.96158
Rp21_im_im_a1 0 x21_im_a1 5.364987040024318e-11
Cx22_re_a1 x22_re_a1 0 1.0
Gx22_re_a1 0 x22_re_a1 p1 0 0.1414213562373095
Fx22_re_a1 0 x22_re_a1 V1 7.0710678118654755
Rp22_re_re_a1 0 x22_re_a1 1.4881900890711124e-10
Gp22_re_im_a1 0 x22_re_a1 x22_im_a1 0 145905244654.2851
Cx22_im_a1 x22_im_a1 0 1.0
Gp22_im_re_a1 0 x22_im_a1 x22_re_a1 0 -145905244654.2851
Rp22_im_im_a1 0 x22_im_a1 1.4881900890711124e-10
Cx23_re_a1 x23_re_a1 0 1.0
Gx23_re_a1 0 x23_re_a1 p1 0 0.1414213562373095
Fx23_re_a1 0 x23_re_a1 V1 7.0710678118654755
Rp23_re_re_a1 0 x23_re_a1 2.3625017483103682e-11
Gp23_re_im_a1 0 x23_re_a1 x23_im_a1 0 72742280962.79858
Cx23_im_a1 x23_im_a1 0 1.0
Gp23_im_re_a1 0 x23_im_a1 x23_re_a1 0 -72742280962.79858
Rp23_im_im_a1 0 x23_im_a1 2.3625017483103682e-11
Cx24_a1 x24_a1 0 1.0
Gx24_a1 0 x24_a1 p1 0 0.07071067811865475
Fx24_a1 0 x24_a1 V1 3.5355339059327378
Rp24_a1 0 x24_a1 8.114490688471263e-11
Cx25_a1 x25_a1 0 1.0
Gx25_a1 0 x25_a1 p1 0 0.07071067811865475
Fx25_a1 0 x25_a1 V1 3.5355339059327378
Rp25_a1 0 x25_a1 2.697569049741469e-10
Cx26_re_a1 x26_re_a1 0 1.0
Gx26_re_a1 0 x26_re_a1 p1 0 0.1414213562373095
Fx26_re_a1 0 x26_re_a1 V1 7.0710678118654755
Rp26_re_re_a1 0 x26_re_a1 1.505175865071392e-10
Gp26_re_im_a1 0 x26_re_a1 x26_im_a1 0 38154119183.271805
Cx26_im_a1 x26_im_a1 0 1.0
Gp26_im_re_a1 0 x26_im_a1 x26_re_a1 0 -38154119183.271805
Rp26_im_im_a1 0 x26_im_a1 1.505175865071392e-10
Cx27_re_a1 x27_re_a1 0 1.0
Gx27_re_a1 0 x27_re_a1 p1 0 0.1414213562373095
Fx27_re_a1 0 x27_re_a1 V1 7.0710678118654755
Rp27_re_re_a1 0 x27_re_a1 1.8778913938448423e-10
Gp27_re_im_a1 0 x27_re_a1 x27_im_a1 0 51586484912.000015
Cx27_im_a1 x27_im_a1 0 1.0
Gp27_im_re_a1 0 x27_im_a1 x27_re_a1 0 -51586484912.000015
Rp27_im_im_a1 0 x27_im_a1 1.8778913938448423e-10
Cx28_re_a1 x28_re_a1 0 1.0
Gx28_re_a1 0 x28_re_a1 p1 0 0.1414213562373095
Fx28_re_a1 0 x28_re_a1 V1 7.0710678118654755
Rp28_re_re_a1 0 x28_re_a1 1.3568282573419268e-10
Gp28_re_im_a1 0 x28_re_a1 x28_im_a1 0 64751348788.93671
Cx28_im_a1 x28_im_a1 0 1.0
Gp28_im_re_a1 0 x28_im_a1 x28_re_a1 0 -64751348788.93671
Rp28_im_im_a1 0 x28_im_a1 1.3568282573419268e-10
Cx29_re_a1 x29_re_a1 0 1.0
Gx29_re_a1 0 x29_re_a1 p1 0 0.1414213562373095
Fx29_re_a1 0 x29_re_a1 V1 7.0710678118654755
Rp29_re_re_a1 0 x29_re_a1 1.3432393259249888e-10
Gp29_re_im_a1 0 x29_re_a1 x29_im_a1 0 75806821045.64723
Cx29_im_a1 x29_im_a1 0 1.0
Gp29_im_re_a1 0 x29_im_a1 x29_re_a1 0 -75806821045.64723
Rp29_im_im_a1 0 x29_im_a1 1.3432393259249888e-10
Cx30_re_a1 x30_re_a1 0 1.0
Gx30_re_a1 0 x30_re_a1 p1 0 0.1414213562373095
Fx30_re_a1 0 x30_re_a1 V1 7.0710678118654755
Rp30_re_re_a1 0 x30_re_a1 1.3897386163275459e-10
Gp30_re_im_a1 0 x30_re_a1 x30_im_a1 0 88025728644.52515
Cx30_im_a1 x30_im_a1 0 1.0
Gp30_im_re_a1 0 x30_im_a1 x30_re_a1 0 -88025728644.52515
Rp30_im_im_a1 0 x30_im_a1 1.3897386163275459e-10
Cx31_re_a1 x31_re_a1 0 1.0
Gx31_re_a1 0 x31_re_a1 p1 0 0.1414213562373095
Fx31_re_a1 0 x31_re_a1 V1 7.0710678118654755
Rp31_re_re_a1 0 x31_re_a1 1.7012749307671338e-10
Gp31_re_im_a1 0 x31_re_a1 x31_im_a1 0 127956729847.8717
Cx31_im_a1 x31_im_a1 0 1.0
Gp31_im_re_a1 0 x31_im_a1 x31_re_a1 0 -127956729847.8717
Rp31_im_im_a1 0 x31_im_a1 1.7012749307671338e-10
Cx32_re_a1 x32_re_a1 0 1.0
Gx32_re_a1 0 x32_re_a1 p1 0 0.1414213562373095
Fx32_re_a1 0 x32_re_a1 V1 7.0710678118654755
Rp32_re_re_a1 0 x32_re_a1 1.368275998516358e-10
Gp32_re_im_a1 0 x32_re_a1 x32_im_a1 0 99914089586.59584
Cx32_im_a1 x32_im_a1 0 1.0
Gp32_im_re_a1 0 x32_im_a1 x32_re_a1 0 -99914089586.59584
Rp32_im_im_a1 0 x32_im_a1 1.368275998516358e-10
Cx33_re_a1 x33_re_a1 0 1.0
Gx33_re_a1 0 x33_re_a1 p1 0 0.1414213562373095
Fx33_re_a1 0 x33_re_a1 V1 7.0710678118654755
Rp33_re_re_a1 0 x33_re_a1 8.025627462525966e-11
Gp33_re_im_a1 0 x33_re_a1 x33_im_a1 0 116712568188.81511
Cx33_im_a1 x33_im_a1 0 1.0
Gp33_im_re_a1 0 x33_im_a1 x33_re_a1 0 -116712568188.81511
Rp33_im_im_a1 0 x33_im_a1 8.025627462525966e-11
Cx34_re_a1 x34_re_a1 0 1.0
Gx34_re_a1 0 x34_re_a1 p1 0 0.1414213562373095
Fx34_re_a1 0 x34_re_a1 V1 7.0710678118654755
Rp34_re_re_a1 0 x34_re_a1 1.1477159643072097e-10
Gp34_re_im_a1 0 x34_re_a1 x34_im_a1 0 111947030522.04149
Cx34_im_a1 x34_im_a1 0 1.0
Gp34_im_re_a1 0 x34_im_a1 x34_re_a1 0 -111947030522.04149
Rp34_im_im_a1 0 x34_im_a1 1.1477159643072097e-10
*
* Port network for port 2
V2 p2 s2 0
R2 s2 0 50.0
Gd2_1 0 s2 p1 0 3.6542009855320414e-05
Fd2_1 0 s2 V1 0.0018271004927660206
Gr1_re_2_1 0 s2 x1_re_a1 0 226094163.74932
Gr1_im_2_1 0 s2 x1_im_a1 0 -519413540.05202645
Gr2_re_2_1 0 s2 x2_re_a1 0 419156355.24182713
Gr2_im_2_1 0 s2 x2_im_a1 0 -161219231.05463833
Gr3_re_2_1 0 s2 x3_re_a1 0 -363478016.2876763
Gr3_im_2_1 0 s2 x3_im_a1 0 613953253.3530663
Gr4_re_2_1 0 s2 x4_re_a1 0 180449387.43647605
Gr4_im_2_1 0 s2 x4_im_a1 0 -106168337.44268805
Gr5_re_2_1 0 s2 x5_re_a1 0 45299879.03175944
Gr5_im_2_1 0 s2 x5_im_a1 0 -424864587.80045533
Gr6_re_2_1 0 s2 x6_re_a1 0 -65539.95305961678
Gr6_im_2_1 0 s2 x6_im_a1 0 261986.96719013204
Gr7_re_2_1 0 s2 x7_re_a1 0 76924114.73043203
Gr7_im_2_1 0 s2 x7_im_a1 0 -170608103.12326837
Gr8_re_2_1 0 s2 x8_re_a1 0 161395005.29919598
Gr8_im_2_1 0 s2 x8_im_a1 0 -335395129.11193115
Gr9_re_2_1 0 s2 x9_re_a1 0 -48658172.19617693
Gr9_im_2_1 0 s2 x9_im_a1 0 -241099415.50469053
Gr10_re_2_1 0 s2 x10_re_a1 0 -382058777.0932911
Gr10_im_2_1 0 s2 x10_im_a1 0 -761678637.1995065
Gr11_re_2_1 0 s2 x11_re_a1 0 -133001995.55892494
Gr11_im_2_1 0 s2 x11_im_a1 0 -149525033.48622212
Gr12_re_2_1 0 s2 x12_re_a1 0 -117900458.61282665
Gr12_im_2_1 0 s2 x12_im_a1 0 -379598284.08580184
Gr13_re_2_1 0 s2 x13_re_a1 0 36194109.43778495
Gr13_im_2_1 0 s2 x13_im_a1 0 -110000246.2116489
Gr14_re_2_1 0 s2 x14_re_a1 0 -123968449.94714728
Gr14_im_2_1 0 s2 x14_im_a1 0 -262606967.00553843
Gr15_re_2_1 0 s2 x15_re_a1 0 -5023442.2208445575
Gr15_im_2_1 0 s2 x15_im_a1 0 -5138244.058302953
Gr16_re_2_1 0 s2 x16_re_a1 0 -18905234.74226429
Gr16_im_2_1 0 s2 x16_im_a1 0 -273585591.951087
Gr17_re_2_1 0 s2 x17_re_a1 0 -97938902.16389255
Gr17_im_2_1 0 s2 x17_im_a1 0 -353924004.0886989
Gr18_2_1 0 s2 x18_a1 0 53267977929.61148
Gr19_re_2_1 0 s2 x19_re_a1 0 1363293132.9809759
Gr19_im_2_1 0 s2 x19_im_a1 0 -553431114.6642883
Gr20_re_2_1 0 s2 x20_re_a1 0 -423692333.3732811
Gr20_im_2_1 0 s2 x20_im_a1 0 754058503.184764
Gr21_re_2_1 0 s2 x21_re_a1 0 -8002896049.084535
Gr21_im_2_1 0 s2 x21_im_a1 0 -5131175857.283969
Gr22_re_2_1 0 s2 x22_re_a1 0 192129104.83239302
Gr22_im_2_1 0 s2 x22_im_a1 0 -69543508.26490234
Gr23_re_2_1 0 s2 x23_re_a1 0 -20009352987.941498
Gr23_im_2_1 0 s2 x23_im_a1 0 25358961133.53025
Gr24_2_1 0 s2 x24_a1 0 48250420.48029783
Gr25_2_1 0 s2 x25_a1 0 3602727.125435118
Gr26_re_2_1 0 s2 x26_re_a1 0 -38867056.389093295
Gr26_im_2_1 0 s2 x26_im_a1 0 34166840.47708263
Gr27_re_2_1 0 s2 x27_re_a1 0 -15274538.877946235
Gr27_im_2_1 0 s2 x27_im_a1 0 23225030.958186917
Gr28_re_2_1 0 s2 x28_re_a1 0 100740320.0380288
Gr28_im_2_1 0 s2 x28_im_a1 0 46536413.574033715
Gr29_re_2_1 0 s2 x29_re_a1 0 -5370637.666690616
Gr29_im_2_1 0 s2 x29_im_a1 0 28722474.809511658
Gr30_re_2_1 0 s2 x30_re_a1 0 42695363.14775609
Gr30_im_2_1 0 s2 x30_im_a1 0 124648120.90267608
Gr31_re_2_1 0 s2 x31_re_a1 0 11944091.562066851
Gr31_im_2_1 0 s2 x31_im_a1 0 -49555681.4268795
Gr32_re_2_1 0 s2 x32_re_a1 0 147025801.9621908
Gr32_im_2_1 0 s2 x32_im_a1 0 201697298.94577134
Gr33_re_2_1 0 s2 x33_re_a1 0 1030591492.5834363
Gr33_im_2_1 0 s2 x33_im_a1 0 -69258063.79945801
Gr34_re_2_1 0 s2 x34_re_a1 0 29454868.443465438
Gr34_im_2_1 0 s2 x34_im_a1 0 -145349519.43479377
Gd2_2 0 s2 p2 0 -7.567664350997779e-05
Fd2_2 0 s2 V2 -0.00378383217549889
Gr1_re_2_2 0 s2 x1_re_a2 0 1126682685.3436594
Gr1_im_2_2 0 s2 x1_im_a2 0 1779465135.967363
Gr2_re_2_2 0 s2 x2_re_a2 0 7772236218.815655
Gr2_im_2_2 0 s2 x2_im_a2 0 3631798449.520099
Gr3_re_2_2 0 s2 x3_re_a2 0 8598684966.873161
Gr3_im_2_2 0 s2 x3_im_a2 0 -3684635873.104857
Gr4_re_2_2 0 s2 x4_re_a2 0 -8781551142.555002
Gr4_im_2_2 0 s2 x4_im_a2 0 -29673455316.807663
Gr5_re_2_2 0 s2 x5_re_a2 0 -14160131063.219261
Gr5_im_2_2 0 s2 x5_im_a2 0 11613452301.449677
Gr6_re_2_2 0 s2 x6_re_a2 0 -249165.19135382044
Gr6_im_2_2 0 s2 x6_im_a2 0 78621.97868579594
Gr7_re_2_2 0 s2 x7_re_a2 0 3714957397.811396
Gr7_im_2_2 0 s2 x7_im_a2 0 -881309815.3154317
Gr8_re_2_2 0 s2 x8_re_a2 0 -10869619285.417404
Gr8_im_2_2 0 s2 x8_im_a2 0 544477911.2497302
Gr9_re_2_2 0 s2 x9_re_a2 0 5216784124.315985
Gr9_im_2_2 0 s2 x9_im_a2 0 -967425510.6849917
Gr10_re_2_2 0 s2 x10_re_a2 0 -19645293278.30867
Gr10_im_2_2 0 s2 x10_im_a2 0 12908324620.283066
Gr11_re_2_2 0 s2 x11_re_a2 0 9337967602.476524
Gr11_im_2_2 0 s2 x11_im_a2 0 6576949671.920144
Gr12_re_2_2 0 s2 x12_re_a2 0 -912243271.4997125
Gr12_im_2_2 0 s2 x12_im_a2 0 -4966083538.043394
Gr13_re_2_2 0 s2 x13_re_a2 0 282801203.7979559
Gr13_im_2_2 0 s2 x13_im_a2 0 582351112.5769161
Gr14_re_2_2 0 s2 x14_re_a2 0 -3391954906.944663
Gr14_im_2_2 0 s2 x14_im_a2 0 3916512361.3664513
Gr15_re_2_2 0 s2 x15_re_a2 0 -379104.21550921653
Gr15_im_2_2 0 s2 x15_im_a2 0 -4246155.578547111
Gr16_re_2_2 0 s2 x16_re_a2 0 1903495523.3947124
Gr16_im_2_2 0 s2 x16_im_a2 0 338922302.2092585
Gr17_re_2_2 0 s2 x17_re_a2 0 -5981543213.856669
Gr17_im_2_2 0 s2 x17_im_a2 0 7025517435.850711
Gr18_2_2 0 s2 x18_a2 0 -34366772229.03624
Gr19_re_2_2 0 s2 x19_re_a2 0 4086730845.0617356
Gr19_im_2_2 0 s2 x19_im_a2 0 12344713789.591055
Gr20_re_2_2 0 s2 x20_re_a2 0 4269597728.26887
Gr20_im_2_2 0 s2 x20_im_a2 0 -2560004519.746826
Gr21_re_2_2 0 s2 x21_re_a2 0 12612293334.37777
Gr21_im_2_2 0 s2 x21_im_a2 0 1534533632.17843
Gr22_re_2_2 0 s2 x22_re_a2 0 77345007.74769038
Gr22_im_2_2 0 s2 x22_im_a2 0 -481980407.30512136
Gr23_re_2_2 0 s2 x23_re_a2 0 10496567528.472223
Gr23_im_2_2 0 s2 x23_im_a2 0 -41984027365.68864
Gr24_2_2 0 s2 x24_a2 0 1623242228.5388525
Gr25_2_2 0 s2 x25_a2 0 -150458602.32006818
Gr26_re_2_2 0 s2 x26_re_a2 0 -654737189.9119335
Gr26_im_2_2 0 s2 x26_im_a2 0 350127252.6540722
Gr27_re_2_2 0 s2 x27_re_a2 0 -403493462.544863
Gr27_im_2_2 0 s2 x27_im_a2 0 328877236.44493437
Gr28_re_2_2 0 s2 x28_re_a2 0 614033985.0701286
Gr28_im_2_2 0 s2 x28_im_a2 0 1498956526.3626268
Gr29_re_2_2 0 s2 x29_re_a2 0 152159629.0459249
Gr29_im_2_2 0 s2 x29_im_a2 0 2106362189.3034277
Gr30_re_2_2 0 s2 x30_re_a2 0 922750345.890782
Gr30_im_2_2 0 s2 x30_im_a2 0 932226931.9498795
Gr31_re_2_2 0 s2 x31_re_a2 0 410054497.5735913
Gr31_im_2_2 0 s2 x31_im_a2 0 -94702814.68968304
Gr32_re_2_2 0 s2 x32_re_a2 0 1691975118.5440013
Gr32_im_2_2 0 s2 x32_im_a2 0 304683971.3374897
Gr33_re_2_2 0 s2 x33_re_a2 0 3291881756.9950814
Gr33_im_2_2 0 s2 x33_im_a2 0 4738713579.085216
Gr34_re_2_2 0 s2 x34_re_a2 0 2188795695.8476987
Gr34_im_2_2 0 s2 x34_im_a2 0 -1249676304.3531039
*
* State networks driven by port 2
Cx1_re_a2 x1_re_a2 0 1.0
Gx1_re_a2 0 x1_re_a2 p2 0 0.1414213562373095
Fx1_re_a2 0 x1_re_a2 V2 7.0710678118654755
Rp1_re_re_a2 0 x1_re_a2 3.516954575863237e-10
Gp1_re_im_a2 0 x1_re_a2 x1_im_a2 0 325797905716.9008
Cx1_im_a2 x1_im_a2 0 1.0
Gp1_im_re_a2 0 x1_im_a2 x1_re_a2 0 -325797905716.9008
Rp1_im_im_a2 0 x1_im_a2 3.516954575863237e-10
Cx2_re_a2 x2_re_a2 0 1.0
Gx2_re_a2 0 x2_re_a2 p2 0 0.1414213562373095
Fx2_re_a2 0 x2_re_a2 V2 7.0710678118654755
Rp2_re_re_a2 0 x2_re_a2 1.0416449466671259e-10
Gp2_re_im_a2 0 x2_re_a2 x2_im_a2 0 307667775748.4361
Cx2_im_a2 x2_im_a2 0 1.0
Gp2_im_re_a2 0 x2_im_a2 x2_re_a2 0 -307667775748.4361
Rp2_im_im_a2 0 x2_im_a2 1.0416449466671259e-10
Cx3_re_a2 x3_re_a2 0 1.0
Gx3_re_a2 0 x3_re_a2 p2 0 0.1414213562373095
Fx3_re_a2 0 x3_re_a2 V2 7.0710678118654755
Rp3_re_re_a2 0 x3_re_a2 1.1947047674594806e-10
Gp3_re_im_a2 0 x3_re_a2 x3_im_a2 0 297169406395.5486
Cx3_im_a2 x3_im_a2 0 1.0
Gp3_im_re_a2 0 x3_im_a2 x3_re_a2 0 -297169406395.5486
Rp3_im_im_a2 0 x3_im_a2 1.1947047674594806e-10
Cx4_re_a2 x4_re_a2 0 1.0
Gx4_re_a2 0 x4_re_a2 p2 0 0.1414213562373095
Fx4_re_a2 0 x4_re_a2 V2 7.0710678118654755
Rp4_re_re_a2 0 x4_re_a2 7.419159539578664e-11
Gp4_re_im_a2 0 x4_re_a2 x4_im_a2 0 286664634627.3183
Cx4_im_a2 x4_im_a2 0 1.0
Gp4_im_re_a2 0 x4_im_a2 x4_re_a2 0 -286664634627.3183
Rp4_im_im_a2 0 x4_im_a2 7.419159539578664e-11
Cx5_re_a2 x5_re_a2 0 1.0
Gx5_re_a2 0 x5_re_a2 p2 0 0.1414213562373095
Fx5_re_a2 0 x5_re_a2 V2 7.0710678118654755
Rp5_re_re_a2 0 x5_re_a2 8.691821820452219e-11
Gp5_re_im_a2 0 x5_re_a2 x5_im_a2 0 276066370424.8892
Cx5_im_a2 x5_im_a2 0 1.0
Gp5_im_re_a2 0 x5_im_a2 x5_re_a2 0 -276066370424.8892
Rp5_im_im_a2 0 x5_im_a2 8.691821820452219e-11
Cx6_re_a2 x6_re_a2 0 1.0
Gx6_re_a2 0 x6_re_a2 p2 0 0.1414213562373095
Fx6_re_a2 0 x6_re_a2 V2 7.0710678118654755
Rp6_re_re_a2 0 x6_re_a2 3.634721588276957e-09
Gp6_re_im_a2 0 x6_re_a2 x6_im_a2 0 262620842188.22052
Cx6_im_a2 x6_im_a2 0 1.0
Gp6_im_re_a2 0 x6_im_a2 x6_re_a2 0 -262620842188.22052
Rp6_im_im_a2 0 x6_im_a2 3.634721588276957e-09
Cx7_re_a2 x7_re_a2 0 1.0
Gx7_re_a2 0 x7_re_a2 p2 0 0.1414213562373095
Fx7_re_a2 0 x7_re_a2 V2 7.0710678118654755
Rp7_re_re_a2 0 x7_re_a2 1.0557552299979523e-10
Gp7_re_im_a2 0 x7_re_a2 x7_im_a2 0 261824227412.7352
Cx7_im_a2 x7_im_a2 0 1.0
Gp7_im_re_a2 0 x7_im_a2 x7_re_a2 0 -261824227412.7352
Rp7_im_im_a2 0 x7_im_a2 1.0557552299979523e-10
Cx8_re_a2 x8_re_a2 0 1.0
Gx8_re_a2 0 x8_re_a2 p2 0 0.1414213562373095
Fx8_re_a2 0 x8_re_a2 V2 7.0710678118654755
Rp8_re_re_a2 0 x8_re_a2 9.178308757909468e-11
Gp8_re_im_a2 0 x8_re_a2 x8_im_a2 0 251179700478.26138
Cx8_im_a2 x8_im_a2 0 1.0
Gp8_im_re_a2 0 x8_im_a2 x8_re_a2 0 -251179700478.26138
Rp8_im_im_a2 0 x8_im_a2 9.178308757909468e-11
Cx9_re_a2 x9_re_a2 0 1.0
Gx9_re_a2 0 x9_re_a2 p2 0 0.1414213562373095
Fx9_re_a2 0 x9_re_a2 V2 7.0710678118654755
Rp9_re_re_a2 0 x9_re_a2 1.0259453872405931e-10
Gp9_re_im_a2 0 x9_re_a2 x9_im_a2 0 242920287375.44836
Cx9_im_a2 x9_im_a2 0 1.0
Gp9_im_re_a2 0 x9_im_a2 x9_re_a2 0 -242920287375.44836
Rp9_im_im_a2 0 x9_im_a2 1.0259453872405931e-10
Cx10_re_a2 x10_re_a2 0 1.0
Gx10_re_a2 0 x10_re_a2 p2 0 0.1414213562373095
Fx10_re_a2 0 x10_re_a2 V2 7.0710678118654755
Rp10_re_re_a2 0 x10_re_a2 6.264244406931637e-11
Gp10_re_im_a2 0 x10_re_a2 x10_im_a2 0 231465146633.18985
Cx10_im_a2 x10_im_a2 0 1.0
Gp10_im_re_a2 0 x10_im_a2 x10_re_a2 0 -231465146633.18985
Rp10_im_im_a2 0 x10_im_a2 6.264244406931637e-11
Cx11_re_a2 x11_re_a2 0 1.0
Gx11_re_a2 0 x11_re_a2 p2 0 0.1414213562373095
Fx11_re_a2 0 x11_re_a2 V2 7.0710678118654755
Rp11_re_re_a2 0 x11_re_a2 1.0672326265370034e-10
Gp11_re_im_a2 0 x11_re_a2 x11_im_a2 0 219100062156.56302
Cx11_im_a2 x11_im_a2 0 1.0
Gp11_im_re_a2 0 x11_im_a2 x11_re_a2 0 -219100062156.56302
Rp11_im_im_a2 0 x11_im_a2 1.0672326265370034e-10
Cx12_re_a2 x12_re_a2 0 1.0
Gx12_re_a2 0 x12_re_a2 p2 0 0.1414213562373095
Fx12_re_a2 0 x12_re_a2 V2 7.0710678118654755
Rp12_re_re_a2 0 x12_re_a2 9.162057604637434e-11
Gp12_re_im_a2 0 x12_re_a2 x12_im_a2 0 207374196420.588
Cx12_im_a2 x12_im_a2 0 1.0
Gp12_im_re_a2 0 x12_im_a2 x12_re_a2 0 -207374196420.588
Rp12_im_im_a2 0 x12_im_a2 9.162057604637434e-11
Cx13_re_a2 x13_re_a2 0 1.0
Gx13_re_a2 0 x13_re_a2 p2 0 0.1414213562373095
Fx13_re_a2 0 x13_re_a2 V2 7.0710678118654755
Rp13_re_re_a2 0 x13_re_a2 1.7288899805088173e-10
Gp13_re_im_a2 0 x13_re_a2 x13_im_a2 0 198534054813.4038
Cx13_im_a2 x13_im_a2 0 1.0
Gp13_im_re_a2 0 x13_im_a2 x13_re_a2 0 -198534054813.4038
Rp13_im_im_a2 0 x13_im_a2 1.7288899805088173e-10
Cx14_re_a2 x14_re_a2 0 1.0
Gx14_re_a2 0 x14_re_a2 p2 0 0.1414213562373095
Fx14_re_a2 0 x14_re_a2 V2 7.0710678118654755
Rp14_re_re_a2 0 x14_re_a2 1.352324940520366e-10
Gp14_re_im_a2 0 x14_re_a2 x14_im_a2 0 193230124137.5904
Cx14_im_a2 x14_im_a2 0 1.0
Gp14_im_re_a2 0 x14_im_a2 x14_re_a2 0 -193230124137.5904
Rp14_im_im_a2 0 x14_im_a2 1.352324940520366e-10
Cx15_re_a2 x15_re_a2 0 1.0
Gx15_re_a2 0 x15_re_a2 p2 0 0.1414213562373095
Fx15_re_a2 0 x15_re_a2 V2 7.0710678118654755
Rp15_re_re_a2 0 x15_re_a2 4.93306865845889e-10
Gp15_re_im_a2 0 x15_re_a2 x15_im_a2 0 188469964612.31436
Cx15_im_a2 x15_im_a2 0 1.0
Gp15_im_re_a2 0 x15_im_a2 x15_re_a2 0 -188469964612.31436
Rp15_im_im_a2 0 x15_im_a2 4.93306865845889e-10
Cx16_re_a2 x16_re_a2 0 1.0
Gx16_re_a2 0 x16_re_a2 p2 0 0.1414213562373095
Fx16_re_a2 0 x16_re_a2 V2 7.0710678118654755
Rp16_re_re_a2 0 x16_re_a2 1.2598956894826076e-10
Gp16_re_im_a2 0 x16_re_a2 x16_im_a2 0 182741455724.2421
Cx16_im_a2 x16_im_a2 0 1.0
Gp16_im_re_a2 0 x16_im_a2 x16_re_a2 0 -182741455724.2421
Rp16_im_im_a2 0 x16_im_a2 1.2598956894826076e-10
Cx17_re_a2 x17_re_a2 0 1.0
Gx17_re_a2 0 x17_re_a2 p2 0 0.1414213562373095
Fx17_re_a2 0 x17_re_a2 V2 7.0710678118654755
Rp17_re_re_a2 0 x17_re_a2 1.1073834394083287e-10
Gp17_re_im_a2 0 x17_re_a2 x17_im_a2 0 174314910045.04767
Cx17_im_a2 x17_im_a2 0 1.0
Gp17_im_re_a2 0 x17_im_a2 x17_re_a2 0 -174314910045.04767
Rp17_im_im_a2 0 x17_im_a2 1.1073834394083287e-10
Cx18_a2 x18_a2 0 1.0
Gx18_a2 0 x18_a2 p2 0 0.07071067811865475
Fx18_a2 0 x18_a2 V2 3.5355339059327378
Rp18_a2 0 x18_a2 1.7929961225020097e-11
Cx19_re_a2 x19_re_a2 0 1.0
Gx19_re_a2 0 x19_re_a2 p2 0 0.1414213562373095
Fx19_re_a2 0 x19_re_a2 V2 7.0710678118654755
Rp19_re_re_a2 0 x19_re_a2 1.1570829433911795e-10
Gp19_re_im_a2 0 x19_re_a2 x19_im_a2 0 161358251608.1025
Cx19_im_a2 x19_im_a2 0 1.0
Gp19_im_re_a2 0 x19_im_a2 x19_re_a2 0 -161358251608.1025
Rp19_im_im_a2 0 x19_im_a2 1.1570829433911795e-10
Cx20_re_a2 x20_re_a2 0 1.0
Gx20_re_a2 0 x20_re_a2 p2 0 0.1414213562373095
Fx20_re_a2 0 x20_re_a2 V2 7.0710678118654755
Rp20_re_re_a2 0 x20_re_a2 1.3008612516807973e-10
Gp20_re_im_a2 0 x20_re_a2 x20_im_a2 0 154920423349.12296
Cx20_im_a2 x20_im_a2 0 1.0
Gp20_im_re_a2 0 x20_im_a2 x20_re_a2 0 -154920423349.12296
Rp20_im_im_a2 0 x20_im_a2 1.3008612516807973e-10
Cx21_re_a2 x21_re_a2 0 1.0
Gx21_re_a2 0 x21_re_a2 p2 0 0.1414213562373095
Fx21_re_a2 0 x21_re_a2 V2 7.0710678118654755
Rp21_re_re_a2 0 x21_re_a2 5.364987040024318e-11
Gp21_re_im_a2 0 x21_re_a2 x21_im_a2 0 144651700109.96158
Cx21_im_a2 x21_im_a2 0 1.0
Gp21_im_re_a2 0 x21_im_a2 x21_re_a2 0 -144651700109.96158
Rp21_im_im_a2 0 x21_im_a2 5.364987040024318e-11
Cx22_re_a2 x22_re_a2 0 1.0
Gx22_re_a2 0 x22_re_a2 p2 0 0.1414213562373095
Fx22_re_a2 0 x22_re_a2 V2 7.0710678118654755
Rp22_re_re_a2 0 x22_re_a2 1.4881900890711124e-10
Gp22_re_im_a2 0 x22_re_a2 x22_im_a2 0 145905244654.2851
Cx22_im_a2 x22_im_a2 0 1.0
Gp22_im_re_a2 0 x22_im_a2 x22_re_a2 0 -145905244654.2851
Rp22_im_im_a2 0 x22_im_a2 1.4881900890711124e-10
Cx23_re_a2 x23_re_a2 0 1.0
Gx23_re_a2 0 x23_re_a2 p2 0 0.1414213562373095
Fx23_re_a2 0 x23_re_a2 V2 7.0710678118654755
Rp23_re_re_a2 0 x23_re_a2 2.3625017483103682e-11
Gp23_re_im_a2 0 x23_re_a2 x23_im_a2 0 72742280962.79858
Cx23_im_a2 x23_im_a2 0 1.0
Gp23_im_re_a2 0 x23_im_a2 x23_re_a2 0 -72742280962.79858
Rp23_im_im_a2 0 x23_im_a2 2.3625017483103682e-11
Cx24_a2 x24_a2 0 1.0
Gx24_a2 0 x24_a2 p2 0 0.07071067811865475
Fx24_a2 0 x24_a2 V2 3.5355339059327378
Rp24_a2 0 x24_a2 8.114490688471263e-11
Cx25_a2 x25_a2 0 1.0
Gx25_a2 0 x25_a2 p2 0 0.07071067811865475
Fx25_a2 0 x25_a2 V2 3.5355339059327378
Rp25_a2 0 x25_a2 2.697569049741469e-10
Cx26_re_a2 x26_re_a2 0 1.0
Gx26_re_a2 0 x26_re_a2 p2 0 0.1414213562373095
Fx26_re_a2 0 x26_re_a2 V2 7.0710678118654755
Rp26_re_re_a2 0 x26_re_a2 1.505175865071392e-10
Gp26_re_im_a2 0 x26_re_a2 x26_im_a2 0 38154119183.271805
Cx26_im_a2 x26_im_a2 0 1.0
Gp26_im_re_a2 0 x26_im_a2 x26_re_a2 0 -38154119183.271805
Rp26_im_im_a2 0 x26_im_a2 1.505175865071392e-10
Cx27_re_a2 x27_re_a2 0 1.0
Gx27_re_a2 0 x27_re_a2 p2 0 0.1414213562373095
Fx27_re_a2 0 x27_re_a2 V2 7.0710678118654755
Rp27_re_re_a2 0 x27_re_a2 1.8778913938448423e-10
Gp27_re_im_a2 0 x27_re_a2 x27_im_a2 0 51586484912.000015
Cx27_im_a2 x27_im_a2 0 1.0
Gp27_im_re_a2 0 x27_im_a2 x27_re_a2 0 -51586484912.000015
Rp27_im_im_a2 0 x27_im_a2 1.8778913938448423e-10
Cx28_re_a2 x28_re_a2 0 1.0
Gx28_re_a2 0 x28_re_a2 p2 0 0.1414213562373095
Fx28_re_a2 0 x28_re_a2 V2 7.0710678118654755
Rp28_re_re_a2 0 x28_re_a2 1.3568282573419268e-10
Gp28_re_im_a2 0 x28_re_a2 x28_im_a2 0 64751348788.93671
Cx28_im_a2 x28_im_a2 0 1.0
Gp28_im_re_a2 0 x28_im_a2 x28_re_a2 0 -64751348788.93671
Rp28_im_im_a2 0 x28_im_a2 1.3568282573419268e-10
Cx29_re_a2 x29_re_a2 0 1.0
Gx29_re_a2 0 x29_re_a2 p2 0 0.1414213562373095
Fx29_re_a2 0 x29_re_a2 V2 7.0710678118654755
Rp29_re_re_a2 0 x29_re_a2 1.3432393259249888e-10
Gp29_re_im_a2 0 x29_re_a2 x29_im_a2 0 75806821045.64723
Cx29_im_a2 x29_im_a2 0 1.0
Gp29_im_re_a2 0 x29_im_a2 x29_re_a2 0 -75806821045.64723
Rp29_im_im_a2 0 x29_im_a2 1.3432393259249888e-10
Cx30_re_a2 x30_re_a2 0 1.0
Gx30_re_a2 0 x30_re_a2 p2 0 0.1414213562373095
Fx30_re_a2 0 x30_re_a2 V2 7.0710678118654755
Rp30_re_re_a2 0 x30_re_a2 1.3897386163275459e-10
Gp30_re_im_a2 0 x30_re_a2 x30_im_a2 0 88025728644.52515
Cx30_im_a2 x30_im_a2 0 1.0
Gp30_im_re_a2 0 x30_im_a2 x30_re_a2 0 -88025728644.52515
Rp30_im_im_a2 0 x30_im_a2 1.3897386163275459e-10
Cx31_re_a2 x31_re_a2 0 1.0
Gx31_re_a2 0 x31_re_a2 p2 0 0.1414213562373095
Fx31_re_a2 0 x31_re_a2 V2 7.0710678118654755
Rp31_re_re_a2 0 x31_re_a2 1.7012749307671338e-10
Gp31_re_im_a2 0 x31_re_a2 x31_im_a2 0 127956729847.8717
Cx31_im_a2 x31_im_a2 0 1.0
Gp31_im_re_a2 0 x31_im_a2 x31_re_a2 0 -127956729847.8717
Rp31_im_im_a2 0 x31_im_a2 1.7012749307671338e-10
Cx32_re_a2 x32_re_a2 0 1.0
Gx32_re_a2 0 x32_re_a2 p2 0 0.1414213562373095
Fx32_re_a2 0 x32_re_a2 V2 7.0710678118654755
Rp32_re_re_a2 0 x32_re_a2 1.368275998516358e-10
Gp32_re_im_a2 0 x32_re_a2 x32_im_a2 0 99914089586.59584
Cx32_im_a2 x32_im_a2 0 1.0
Gp32_im_re_a2 0 x32_im_a2 x32_re_a2 0 -99914089586.59584
Rp32_im_im_a2 0 x32_im_a2 1.368275998516358e-10
Cx33_re_a2 x33_re_a2 0 1.0
Gx33_re_a2 0 x33_re_a2 p2 0 0.1414213562373095
Fx33_re_a2 0 x33_re_a2 V2 7.0710678118654755
Rp33_re_re_a2 0 x33_re_a2 8.025627462525966e-11
Gp33_re_im_a2 0 x33_re_a2 x33_im_a2 0 116712568188.81511
Cx33_im_a2 x33_im_a2 0 1.0
Gp33_im_re_a2 0 x33_im_a2 x33_re_a2 0 -116712568188.81511
Rp33_im_im_a2 0 x33_im_a2 8.025627462525966e-11
Cx34_re_a2 x34_re_a2 0 1.0
Gx34_re_a2 0 x34_re_a2 p2 0 0.1414213562373095
Fx34_re_a2 0 x34_re_a2 V2 7.0710678118654755
Rp34_re_re_a2 0 x34_re_a2 1.1477159643072097e-10
Gp34_re_im_a2 0 x34_re_a2 x34_im_a2 0 111947030522.04149
Cx34_im_a2 x34_im_a2 0 1.0
Gp34_im_re_a2 0 x34_im_a2 x34_re_a2 0 -111947030522.04149
Rp34_im_im_a2 0 x34_im_a2 1.1477159643072097e-10
.ENDS s_equivalent
