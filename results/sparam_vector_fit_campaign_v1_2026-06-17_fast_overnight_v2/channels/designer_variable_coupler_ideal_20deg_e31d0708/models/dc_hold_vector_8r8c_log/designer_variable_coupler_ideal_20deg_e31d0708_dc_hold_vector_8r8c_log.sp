* EQUIVALENT CIRCUIT FOR VECTOR FITTED S-MATRIX
* Created using scikit-rf vectorFitting.py
*
.SUBCKT s_equivalent p1 p2 p3 p4
*
* Port network for port 1
V1 p1 s1 0
R1 s1 0 50.0
Gd1_1 0 s1 p1 0 -2.497683263596072e-17
Fd1_1 0 s1 V1 -1.248841631798036e-15
Gr1_1_1 0 s1 x1_a1 0 55.15034134996286
Gr2_1_1 0 s1 x2_a1 0 0.004741964035217568
Gr3_1_1 0 s1 x3_a1 0 7.442143759490806e-06
Gr4_1_1 0 s1 x4_a1 0 7.825060911838777e-08
Gr5_1_1 0 s1 x5_a1 0 7.828264917517411e-08
Gr6_1_1 0 s1 x6_a1 0 5.035270191244426e-08
Gr7_1_1 0 s1 x7_a1 0 1.8111498987645875e-08
Gr8_1_1 0 s1 x8_a1 0 5.285929693568599e-09
Gr9_1_1 0 s1 x9_a1 0 2.5876684050339597e-09
Gr10_re_1_1 0 s1 x10_re_a1 0 3.7173674547308597e-10
Gr10_im_1_1 0 s1 x10_im_a1 0 -4.13084748218474e-15
Gr11_1_1 0 s1 x11_a1 0 3.9938531546323657e-10
Gr12_1_1 0 s1 x12_a1 0 7.657843394319825e-11
Gr13_1_1 0 s1 x13_a1 0 3.524942929923418e-11
Gr14_1_1 0 s1 x14_a1 0 1.6655057488662417e-11
Gr15_1_1 0 s1 x15_a1 0 5.345841144939901e-12
Gr16_1_1 0 s1 x16_a1 0 1.0117345135731464e-12
Gr17_1_1 0 s1 x17_a1 0 9.066977813852135e-14
Gr18_1_1 0 s1 x18_a1 0 6.4337656748480705e-15
Gr19_1_1 0 s1 x19_a1 0 2.197444469272355e-16
Gr20_1_1 0 s1 x20_a1 0 1.6165585674583558e-18
Gr21_1_1 0 s1 x21_a1 0 2.7169963750464364e-22
Gr22_1_1 0 s1 x22_a1 0 4.267242364006378e-30
Gr23_1_1 0 s1 x23_a1 0 1.1639867912742387e-50
Gd1_2 0 s1 p2 0 -0.04872347889846373
Fd1_2 0 s1 V2 -2.4361739449231865
Gr1_1_2 0 s1 x1_a2 0 -8.908389562497819e+16
Gr2_1_2 0 s1 x2_a2 0 -7643300805985.605
Gr3_1_2 0 s1 x3_a2 0 4330412841.807331
Gr4_1_2 0 s1 x4_a2 0 152552171.6873091
Gr5_1_2 0 s1 x5_a2 0 152614553.93398425
Gr6_1_2 0 s1 x6_a2 0 98214347.19421265
Gr7_1_2 0 s1 x7_a2 0 35355951.2908376
Gr8_1_2 0 s1 x8_a2 0 10324596.872732012
Gr9_1_2 0 s1 x9_a2 0 5055290.582879006
Gr10_re_1_2 0 s1 x10_re_a2 0 726407.4934523914
Gr10_im_1_2 0 s1 x10_im_a2 0 -395.88983607577836
Gr11_1_2 0 s1 x11_a2 0 780460.3462752155
Gr12_1_2 0 s1 x12_a2 0 149661.23388728438
Gr13_1_2 0 s1 x13_a2 0 68891.5529270161
Gr14_1_2 0 s1 x14_a2 0 32551.222635760398
Gr15_1_2 0 s1 x15_a2 0 10448.26457910195
Gr16_1_2 0 s1 x16_a2 0 1977.4240175977195
Gr17_1_2 0 s1 x17_a2 0 177.21421626473378
Gr18_1_2 0 s1 x18_a2 0 12.574829687923382
Gr19_1_2 0 s1 x19_a2 0 0.42949195969144105
Gr20_1_2 0 s1 x20_a2 0 0.0031595746870512836
Gr21_1_2 0 s1 x21_a2 0 5.310387907731432e-07
Gr22_1_2 0 s1 x22_a2 0 8.340354245841338e-15
Gr23_1_2 0 s1 x23_a2 0 2.2750201063323072e-35
Gd1_3 0 s1 p3 0 0.27633092313770735
Fd1_3 0 s1 V3 13.816546156885368
Gr1_1_3 0 s1 x1_a3 0 5.051382478361246e+17
Gr2_1_3 0 s1 x2_a3 0 43340299788812.99
Gr3_1_3 0 s1 x3_a3 0 -24564384505.194836
Gr4_1_3 0 s1 x4_a3 0 -865186262.8723525
Gr5_1_3 0 s1 x5_a3 0 -865540058.351816
Gr6_1_3 0 s1 x6_a3 0 -557014032.9441202
Gr7_1_3 0 s1 x7_a3 0 -200518154.73887444
Gr8_1_3 0 s1 x8_a3 0 -58555036.44502276
Gr9_1_3 0 s1 x9_a3 0 -28670632.1892595
Gr10_re_1_3 0 s1 x10_re_a3 0 -4119755.5893904692
Gr10_im_1_3 0 s1 x10_im_a3 0 2245.0705239032627
Gr11_1_3 0 s1 x11_a3 0 -4426311.532086171
Gr12_1_3 0 s1 x12_a3 0 -848790.3876370775
Gr13_1_3 0 s1 x13_a3 0 -390712.31922241463
Gr14_1_3 0 s1 x14_a3 0 -184611.36571009282
Gr15_1_3 0 s1 x15_a3 0 -59256.403738176574
Gr16_1_3 0 s1 x16_a3 0 -11214.784517163429
Gr17_1_3 0 s1 x17_a3 0 -1005.0546721615365
Gr18_1_3 0 s1 x18_a3 0 -71.31702858701861
Gr19_1_3 0 s1 x19_a3 0 -2.435825464508335
Gr20_1_3 0 s1 x20_a3 0 -0.017919246928827202
Gr21_1_3 0 s1 x21_a3 0 -3.0117392887210145e-06
Gr22_1_3 0 s1 x22_a3 0 -4.7301577588108544e-14
Gr23_1_3 0 s1 x23_a3 0 -1.2902574267494934e-34
Gd1_4 0 s1 p4 0 3.8111892817247596e-17
Fd1_4 0 s1 V4 1.90559464086238e-15
Gr1_1_4 0 s1 x1_a4 0 116.28649248930479
Gr2_1_4 0 s1 x2_a4 0 0.00998193435242724
Gr3_1_4 0 s1 x3_a4 0 -9.731986973792369e-07
Gr4_1_4 0 s1 x4_a4 0 -1.193050193219913e-07
Gr5_1_4 0 s1 x5_a4 0 -1.1935378682390994e-07
Gr6_1_4 0 s1 x6_a4 0 -7.682142993135385e-08
Gr7_1_4 0 s1 x7_a4 0 -2.7661630787323845e-08
Gr8_1_4 0 s1 x8_a4 0 -8.079082769027482e-09
Gr9_1_4 0 s1 x9_a4 0 -3.956043141484901e-09
Gr10_re_1_4 0 s1 x10_re_a4 0 -5.684963180541869e-10
Gr10_im_1_4 0 s1 x10_im_a4 0 4.015724056702523e-13
Gr11_1_4 0 s1 x11_a4 0 -6.108047312215088e-10
Gr12_1_4 0 s1 x12_a4 0 -1.1713163292675654e-10
Gr13_1_4 0 s1 x13_a4 0 -5.391805141414379e-11
Gr14_1_4 0 s1 x14_a4 0 -2.547638016694413e-11
Gr15_1_4 0 s1 x15_a4 0 -8.177426988822084e-12
Gr16_1_4 0 s1 x16_a4 0 -1.5476539759298185e-12
Gr17_1_4 0 s1 x17_a4 0 -1.3869904068592683e-13
Gr18_1_4 0 s1 x18_a4 0 -9.841862032825449e-15
Gr19_1_4 0 s1 x19_a4 0 -3.3614780249398474e-16
Gr20_1_4 0 s1 x20_a4 0 -2.4728847728397306e-18
Gr21_1_4 0 s1 x21_a4 0 -4.1562484639870775e-22
Gr22_1_4 0 s1 x22_a4 0 -6.527693480635953e-30
Gr23_1_4 0 s1 x23_a4 0 -1.7805759178425793e-50
*
* State networks driven by port 1
Cx1_a1 x1_a1 0 1.0
Gx1_a1 0 x1_a1 p1 0 0.07071067811865475
Fx1_a1 0 x1_a1 V1 3.5355339059327378
Rp1_a1 0 x1_a1 1.320394725695103e-19
Cx2_a1 x2_a1 0 1.0
Gx2_a1 0 x2_a1 p1 0 0.07071067811865475
Fx2_a1 0 x2_a1 V1 3.5355339059327378
Rp2_a1 0 x2_a1 1.5371403703198e-15
Cx3_a1 x3_a1 0 1.0
Gx3_a1 0 x3_a1 p1 0 0.07071067811865475
Fx3_a1 0 x3_a1 V1 3.5355339059327378
Rp3_a1 0 x3_a1 2.5440136148156124e-12
Cx4_a1 x4_a1 0 1.0
Gx4_a1 0 x4_a1 p1 0 0.07071067811865475
Fx4_a1 0 x4_a1 V1 3.5355339059327378
Rp4_a1 0 x4_a1 1.1391706101106968e-09
Cx5_a1 x5_a1 0 1.0
Gx5_a1 0 x5_a1 p1 0 0.07071067811865475
Fx5_a1 0 x5_a1 V1 3.5355339059327378
Rp5_a1 0 x5_a1 1.138933584838299e-09
Cx6_a1 x6_a1 0 1.0
Gx6_a1 0 x6_a1 p1 0 0.07071067811865475
Fx6_a1 0 x6_a1 V1 3.5355339059327378
Rp6_a1 0 x6_a1 1.424292178555483e-09
Cx7_a1 x7_a1 0 1.0
Gx7_a1 0 x7_a1 p1 0 0.07071067811865475
Fx7_a1 0 x7_a1 V1 3.5355339059327378
Rp7_a1 0 x7_a1 2.382721558974834e-09
Cx8_a1 x8_a1 0 1.0
Gx8_a1 0 x8_a1 p1 0 0.07071067811865475
Fx8_a1 0 x8_a1 V1 3.5355339059327378
Rp8_a1 0 x8_a1 4.416030416500193e-09
Cx9_a1 x9_a1 0 1.0
Gx9_a1 0 x9_a1 p1 0 0.07071067811865475
Fx9_a1 0 x9_a1 V1 3.5355339059327378
Rp9_a1 0 x9_a1 6.3131031797856016e-09
Cx10_re_a1 x10_re_a1 0 1.0
Gx10_re_a1 0 x10_re_a1 p1 0 0.1414213562373095
Fx10_re_a1 0 x10_re_a1 V1 7.0710678118654755
Rp10_re_re_a1 0 x10_re_a1 1.3649019396502693e-08
Gp10_re_im_a1 0 x10_re_a1 x10_im_a1 0 29187174.347286176
Cx10_im_a1 x10_im_a1 0 1.0
Gp10_im_re_a1 0 x10_im_a1 x10_re_a1 0 -29187174.347286176
Rp10_im_im_a1 0 x10_im_a1 1.3649019396502693e-08
Cx11_a1 x11_a1 0 1.0
Gx11_a1 0 x11_a1 p1 0 0.07071067811865475
Fx11_a1 0 x11_a1 V1 3.5355339059327378
Rp11_a1 0 x11_a1 1.6072064937358477e-08
Cx12_a1 x12_a1 0 1.0
Gx12_a1 0 x12_a1 p1 0 0.07071067811865475
Fx12_a1 0 x12_a1 V1 3.5355339059327378
Rp12_a1 0 x12_a1 3.670436481000849e-08
Cx13_a1 x13_a1 0 1.0
Gx13_a1 0 x13_a1 p1 0 0.07071067811865475
Fx13_a1 0 x13_a1 V1 3.5355339059327378
Rp13_a1 0 x13_a1 5.4099573770772176e-08
Cx14_a1 x14_a1 0 1.0
Gx14_a1 0 x14_a1 p1 0 0.07071067811865475
Fx14_a1 0 x14_a1 V1 3.5355339059327378
Rp14_a1 0 x14_a1 7.870380105648126e-08
Cx15_a1 x15_a1 0 1.0
Gx15_a1 0 x15_a1 p1 0 0.07071067811865475
Fx15_a1 0 x15_a1 V1 3.5355339059327378
Rp15_a1 0 x15_a1 1.389182763668471e-07
Cx16_a1 x16_a1 0 1.0
Gx16_a1 0 x16_a1 p1 0 0.07071067811865475
Fx16_a1 0 x16_a1 V1 3.5355339059327378
Rp16_a1 0 x16_a1 3.1932500668354715e-07
Cx17_a1 x17_a1 0 1.0
Gx17_a1 0 x17_a1 p1 0 0.07071067811865475
Fx17_a1 0 x17_a1 V1 3.5355339059327378
Rp17_a1 0 x17_a1 1.066680172722843e-06
Cx18_a1 x18_a1 0 1.0
Gx18_a1 0 x18_a1 p1 0 0.07071067811865475
Fx18_a1 0 x18_a1 V1 3.5355339059327378
Rp18_a1 0 x18_a1 4.004355680703426e-06
Cx19_a1 x19_a1 0 1.0
Gx19_a1 0 x19_a1 p1 0 0.07071067811865475
Fx19_a1 0 x19_a1 V1 3.5355339059327378
Rp19_a1 0 x19_a1 2.16673720806938e-05
Cx20_a1 x20_a1 0 1.0
Gx20_a1 0 x20_a1 p1 0 0.07071067811865475
Fx20_a1 0 x20_a1 V1 3.5355339059327378
Rp20_a1 0 x20_a1 0.0002526210055012289
Cx21_a1 x21_a1 0 1.0
Gx21_a1 0 x21_a1 p1 0 0.07071067811865475
Fx21_a1 0 x21_a1 V1 3.5355339059327378
Rp21_a1 0 x21_a1 0.019485908117322464
Cx22_a1 x22_a1 0 1.0
Gx22_a1 0 x22_a1 p1 0 0.07071067811865475
Fx22_a1 0 x22_a1 V1 3.5355339059327378
Rp22_a1 0 x22_a1 155.48608368887304
Cx23_a1 x23_a1 0 1.0
Gx23_a1 0 x23_a1 p1 0 0.07071067811865475
Fx23_a1 0 x23_a1 V1 3.5355339059327378
Rp23_a1 0 x23_a1 2977084446687.4565
*
* Port network for port 2
V2 p2 s2 0
R2 s2 0 50.0
Gd2_1 0 s2 p1 0 -0.04872347889846373
Fd2_1 0 s2 V1 -2.4361739449231865
Gr1_2_1 0 s2 x1_a1 0 -8.908389562497827e+16
Gr2_2_1 0 s2 x2_a1 0 -7643300805985.612
Gr3_2_1 0 s2 x3_a1 0 4330412841.807327
Gr4_2_1 0 s2 x4_a1 0 152552171.6873091
Gr5_2_1 0 s2 x5_a1 0 152614553.93398425
Gr6_2_1 0 s2 x6_a1 0 98214347.19421265
Gr7_2_1 0 s2 x7_a1 0 35355951.2908376
Gr8_2_1 0 s2 x8_a1 0 10324596.872732012
Gr9_2_1 0 s2 x9_a1 0 5055290.582879006
Gr10_re_2_1 0 s2 x10_re_a1 0 726407.4934523914
Gr10_im_2_1 0 s2 x10_im_a1 0 -395.88983607577853
Gr11_2_1 0 s2 x11_a1 0 780460.3462752155
Gr12_2_1 0 s2 x12_a1 0 149661.23388728438
Gr13_2_1 0 s2 x13_a1 0 68891.5529270161
Gr14_2_1 0 s2 x14_a1 0 32551.222635760398
Gr15_2_1 0 s2 x15_a1 0 10448.26457910195
Gr16_2_1 0 s2 x16_a1 0 1977.4240175977195
Gr17_2_1 0 s2 x17_a1 0 177.21421626473378
Gr18_2_1 0 s2 x18_a1 0 12.574829687923382
Gr19_2_1 0 s2 x19_a1 0 0.42949195969144105
Gr20_2_1 0 s2 x20_a1 0 0.0031595746870512836
Gr21_2_1 0 s2 x21_a1 0 5.310387907731432e-07
Gr22_2_1 0 s2 x22_a1 0 8.340354245841338e-15
Gr23_2_1 0 s2 x23_a1 0 2.2750201063323072e-35
Gd2_2 0 s2 p2 0 -3.9190880563256575e-17
Fd2_2 0 s2 V2 -1.959544028162829e-15
Gr1_2_2 0 s2 x1_a2 0 35.45299604797913
Gr2_2_2 0 s2 x2_a2 0 0.0030525851602473037
Gr3_2_2 0 s2 x3_a2 0 9.031321542080966e-06
Gr4_2_2 0 s2 x4_a2 0 1.2275752718755975e-07
Gr5_2_2 0 s2 x5_a2 0 1.2280776978184466e-07
Gr6_2_2 0 s2 x6_a2 0 7.90050202773705e-08
Gr7_2_2 0 s2 x7_a2 0 2.8425052788198543e-08
Gr8_2_2 0 s2 x8_a2 0 8.297494608920883e-09
Gr9_2_2 0 s2 x9_a2 0 4.062206019213146e-09
Gr10_re_2_2 0 s2 x10_re_a2 0 5.836110527682951e-10
Gr10_im_2_2 0 s2 x10_im_a2 0 -1.0721744573172497e-13
Gr11_2_2 0 s2 x11_a2 0 6.270246449148051e-10
Gr12_2_2 0 s2 x12_a2 0 1.202301126510134e-10
Gr13_2_2 0 s2 x13_a2 0 5.534296644843416e-11
Gr14_2_2 0 s2 x14_a2 0 2.614922582297626e-11
Gr15_2_2 0 s2 x15_a2 0 8.3932661289949e-12
Gr16_2_2 0 s2 x16_a2 0 1.5884851808804975e-12
Gr17_2_2 0 s2 x17_a2 0 1.4235740068215526e-13
Gr18_2_2 0 s2 x18_a2 0 1.0101433665158844e-14
Gr19_2_2 0 s2 x19_a2 0 3.4501324577824256e-16
Gr20_2_2 0 s2 x20_a2 0 2.5381034571576524e-18
Gr21_2_2 0 s2 x21_a2 0 4.265863332574347e-22
Gr22_2_2 0 s2 x22_a2 0 6.699851681763201e-30
Gr23_2_2 0 s2 x23_a2 0 1.8275359578468163e-50
Gd2_3 0 s2 p3 0 2.0065456527621036e-17
Fd2_3 0 s2 V3 1.0032728263810518e-15
Gr1_2_3 0 s2 x1_a3 0 126.98153605126221
Gr2_2_3 0 s2 x2_a3 0 0.010903945227825219
Gr3_2_3 0 s2 x3_a3 0 2.893861453754101e-06
Gr4_2_3 0 s2 x4_a3 0 -6.278091679285661e-08
Gr5_2_3 0 s2 x5_a3 0 -6.280655224569008e-08
Gr6_2_3 0 s2 x6_a3 0 -4.044187761495252e-08
Gr7_2_3 0 s2 x7_a3 0 -1.4571877599982434e-08
Gr8_2_3 0 s2 x8_a3 0 -4.2579160230924405e-09
Gr9_2_3 0 s2 x9_a3 0 -2.085285238058139e-09
Gr10_re_2_3 0 s2 x10_re_a3 0 -2.997221969685928e-10
Gr10_im_2_3 0 s2 x10_im_a3 0 3.4109862570586526e-13
Gr11_2_3 0 s2 x11_a3 0 -3.220363555513999e-10
Gr12_2_3 0 s2 x12_a3 0 -6.176072016838462e-11
Gr13_2_3 0 s2 x13_a3 0 -2.843028861069484e-11
Gr14_2_3 0 s2 x14_a3 0 -1.3433546676381356e-11
Gr15_2_3 0 s2 x15_a3 0 -4.3119652699400065e-12
Gr16_2_3 0 s2 x16_a3 0 -8.160872450555004e-13
Gr17_2_3 0 s2 x17_a3 0 -7.313721437404715e-14
Gr18_2_3 0 s2 x18_a3 0 -5.189708098219407e-15
Gr19_2_3 0 s2 x19_a3 0 -1.7725403994578318e-16
Gr20_2_3 0 s2 x20_a3 0 -1.3039765735195943e-18
Gr21_2_3 0 s2 x21_a3 0 -2.191630900058874e-22
Gr22_2_3 0 s2 x22_a3 0 -3.442117299761406e-30
Gr23_2_3 0 s2 x23_a3 0 -9.38915282791047e-51
Gd2_4 0 s2 p4 0 0.27633092313770735
Fd2_4 0 s2 V4 13.816546156885368
Gr1_2_4 0 s2 x1_a4 0 5.051382478361246e+17
Gr2_2_4 0 s2 x2_a4 0 43340299788812.99
Gr3_2_4 0 s2 x3_a4 0 -24564384505.194836
Gr4_2_4 0 s2 x4_a4 0 -865186262.8723525
Gr5_2_4 0 s2 x5_a4 0 -865540058.351816
Gr6_2_4 0 s2 x6_a4 0 -557014032.9441202
Gr7_2_4 0 s2 x7_a4 0 -200518154.73887444
Gr8_2_4 0 s2 x8_a4 0 -58555036.44502276
Gr9_2_4 0 s2 x9_a4 0 -28670632.1892595
Gr10_re_2_4 0 s2 x10_re_a4 0 -4119755.5893904692
Gr10_im_2_4 0 s2 x10_im_a4 0 2245.0705239032627
Gr11_2_4 0 s2 x11_a4 0 -4426311.532086171
Gr12_2_4 0 s2 x12_a4 0 -848790.3876370775
Gr13_2_4 0 s2 x13_a4 0 -390712.31922241463
Gr14_2_4 0 s2 x14_a4 0 -184611.36571009282
Gr15_2_4 0 s2 x15_a4 0 -59256.403738176574
Gr16_2_4 0 s2 x16_a4 0 -11214.784517163429
Gr17_2_4 0 s2 x17_a4 0 -1005.0546721615365
Gr18_2_4 0 s2 x18_a4 0 -71.31702858701861
Gr19_2_4 0 s2 x19_a4 0 -2.435825464508335
Gr20_2_4 0 s2 x20_a4 0 -0.017919246928827202
Gr21_2_4 0 s2 x21_a4 0 -3.0117392887210145e-06
Gr22_2_4 0 s2 x22_a4 0 -4.7301577588108544e-14
Gr23_2_4 0 s2 x23_a4 0 -1.2902574267494934e-34
*
* State networks driven by port 2
Cx1_a2 x1_a2 0 1.0
Gx1_a2 0 x1_a2 p2 0 0.07071067811865475
Fx1_a2 0 x1_a2 V2 3.5355339059327378
Rp1_a2 0 x1_a2 1.320394725695103e-19
Cx2_a2 x2_a2 0 1.0
Gx2_a2 0 x2_a2 p2 0 0.07071067811865475
Fx2_a2 0 x2_a2 V2 3.5355339059327378
Rp2_a2 0 x2_a2 1.5371403703198e-15
Cx3_a2 x3_a2 0 1.0
Gx3_a2 0 x3_a2 p2 0 0.07071067811865475
Fx3_a2 0 x3_a2 V2 3.5355339059327378
Rp3_a2 0 x3_a2 2.5440136148156124e-12
Cx4_a2 x4_a2 0 1.0
Gx4_a2 0 x4_a2 p2 0 0.07071067811865475
Fx4_a2 0 x4_a2 V2 3.5355339059327378
Rp4_a2 0 x4_a2 1.1391706101106968e-09
Cx5_a2 x5_a2 0 1.0
Gx5_a2 0 x5_a2 p2 0 0.07071067811865475
Fx5_a2 0 x5_a2 V2 3.5355339059327378
Rp5_a2 0 x5_a2 1.138933584838299e-09
Cx6_a2 x6_a2 0 1.0
Gx6_a2 0 x6_a2 p2 0 0.07071067811865475
Fx6_a2 0 x6_a2 V2 3.5355339059327378
Rp6_a2 0 x6_a2 1.424292178555483e-09
Cx7_a2 x7_a2 0 1.0
Gx7_a2 0 x7_a2 p2 0 0.07071067811865475
Fx7_a2 0 x7_a2 V2 3.5355339059327378
Rp7_a2 0 x7_a2 2.382721558974834e-09
Cx8_a2 x8_a2 0 1.0
Gx8_a2 0 x8_a2 p2 0 0.07071067811865475
Fx8_a2 0 x8_a2 V2 3.5355339059327378
Rp8_a2 0 x8_a2 4.416030416500193e-09
Cx9_a2 x9_a2 0 1.0
Gx9_a2 0 x9_a2 p2 0 0.07071067811865475
Fx9_a2 0 x9_a2 V2 3.5355339059327378
Rp9_a2 0 x9_a2 6.3131031797856016e-09
Cx10_re_a2 x10_re_a2 0 1.0
Gx10_re_a2 0 x10_re_a2 p2 0 0.1414213562373095
Fx10_re_a2 0 x10_re_a2 V2 7.0710678118654755
Rp10_re_re_a2 0 x10_re_a2 1.3649019396502693e-08
Gp10_re_im_a2 0 x10_re_a2 x10_im_a2 0 29187174.347286176
Cx10_im_a2 x10_im_a2 0 1.0
Gp10_im_re_a2 0 x10_im_a2 x10_re_a2 0 -29187174.347286176
Rp10_im_im_a2 0 x10_im_a2 1.3649019396502693e-08
Cx11_a2 x11_a2 0 1.0
Gx11_a2 0 x11_a2 p2 0 0.07071067811865475
Fx11_a2 0 x11_a2 V2 3.5355339059327378
Rp11_a2 0 x11_a2 1.6072064937358477e-08
Cx12_a2 x12_a2 0 1.0
Gx12_a2 0 x12_a2 p2 0 0.07071067811865475
Fx12_a2 0 x12_a2 V2 3.5355339059327378
Rp12_a2 0 x12_a2 3.670436481000849e-08
Cx13_a2 x13_a2 0 1.0
Gx13_a2 0 x13_a2 p2 0 0.07071067811865475
Fx13_a2 0 x13_a2 V2 3.5355339059327378
Rp13_a2 0 x13_a2 5.4099573770772176e-08
Cx14_a2 x14_a2 0 1.0
Gx14_a2 0 x14_a2 p2 0 0.07071067811865475
Fx14_a2 0 x14_a2 V2 3.5355339059327378
Rp14_a2 0 x14_a2 7.870380105648126e-08
Cx15_a2 x15_a2 0 1.0
Gx15_a2 0 x15_a2 p2 0 0.07071067811865475
Fx15_a2 0 x15_a2 V2 3.5355339059327378
Rp15_a2 0 x15_a2 1.389182763668471e-07
Cx16_a2 x16_a2 0 1.0
Gx16_a2 0 x16_a2 p2 0 0.07071067811865475
Fx16_a2 0 x16_a2 V2 3.5355339059327378
Rp16_a2 0 x16_a2 3.1932500668354715e-07
Cx17_a2 x17_a2 0 1.0
Gx17_a2 0 x17_a2 p2 0 0.07071067811865475
Fx17_a2 0 x17_a2 V2 3.5355339059327378
Rp17_a2 0 x17_a2 1.066680172722843e-06
Cx18_a2 x18_a2 0 1.0
Gx18_a2 0 x18_a2 p2 0 0.07071067811865475
Fx18_a2 0 x18_a2 V2 3.5355339059327378
Rp18_a2 0 x18_a2 4.004355680703426e-06
Cx19_a2 x19_a2 0 1.0
Gx19_a2 0 x19_a2 p2 0 0.07071067811865475
Fx19_a2 0 x19_a2 V2 3.5355339059327378
Rp19_a2 0 x19_a2 2.16673720806938e-05
Cx20_a2 x20_a2 0 1.0
Gx20_a2 0 x20_a2 p2 0 0.07071067811865475
Fx20_a2 0 x20_a2 V2 3.5355339059327378
Rp20_a2 0 x20_a2 0.0002526210055012289
Cx21_a2 x21_a2 0 1.0
Gx21_a2 0 x21_a2 p2 0 0.07071067811865475
Fx21_a2 0 x21_a2 V2 3.5355339059327378
Rp21_a2 0 x21_a2 0.019485908117322464
Cx22_a2 x22_a2 0 1.0
Gx22_a2 0 x22_a2 p2 0 0.07071067811865475
Fx22_a2 0 x22_a2 V2 3.5355339059327378
Rp22_a2 0 x22_a2 155.48608368887304
Cx23_a2 x23_a2 0 1.0
Gx23_a2 0 x23_a2 p2 0 0.07071067811865475
Fx23_a2 0 x23_a2 V2 3.5355339059327378
Rp23_a2 0 x23_a2 2977084446687.4565
*
* Port network for port 3
V3 p3 s3 0
R3 s3 0 50.0
Gd3_1 0 s3 p1 0 0.27633092313770735
Fd3_1 0 s3 V1 13.816546156885368
Gr1_3_1 0 s3 x1_a1 0 5.051382478361246e+17
Gr2_3_1 0 s3 x2_a1 0 43340299788812.99
Gr3_3_1 0 s3 x3_a1 0 -24564384505.194836
Gr4_3_1 0 s3 x4_a1 0 -865186262.8723525
Gr5_3_1 0 s3 x5_a1 0 -865540058.351816
Gr6_3_1 0 s3 x6_a1 0 -557014032.9441202
Gr7_3_1 0 s3 x7_a1 0 -200518154.73887444
Gr8_3_1 0 s3 x8_a1 0 -58555036.44502276
Gr9_3_1 0 s3 x9_a1 0 -28670632.1892595
Gr10_re_3_1 0 s3 x10_re_a1 0 -4119755.5893904692
Gr10_im_3_1 0 s3 x10_im_a1 0 2245.0705239032627
Gr11_3_1 0 s3 x11_a1 0 -4426311.532086171
Gr12_3_1 0 s3 x12_a1 0 -848790.3876370775
Gr13_3_1 0 s3 x13_a1 0 -390712.31922241463
Gr14_3_1 0 s3 x14_a1 0 -184611.36571009282
Gr15_3_1 0 s3 x15_a1 0 -59256.403738176574
Gr16_3_1 0 s3 x16_a1 0 -11214.784517163429
Gr17_3_1 0 s3 x17_a1 0 -1005.0546721615365
Gr18_3_1 0 s3 x18_a1 0 -71.31702858701861
Gr19_3_1 0 s3 x19_a1 0 -2.435825464508335
Gr20_3_1 0 s3 x20_a1 0 -0.017919246928827202
Gr21_3_1 0 s3 x21_a1 0 -3.0117392887210145e-06
Gr22_3_1 0 s3 x22_a1 0 -4.7301577588108544e-14
Gr23_3_1 0 s3 x23_a1 0 -1.2902574267494934e-34
Gd3_2 0 s3 p2 0 3.948346646471048e-17
Fd3_2 0 s3 V2 1.974173323235524e-15
Gr1_3_2 0 s3 x1_a2 0 54.714848061065446
Gr2_3_2 0 s3 x2_a2 0 0.004692719097139602
Gr3_3_2 0 s3 x3_a2 0 -4.414382729417089e-06
Gr4_3_2 0 s3 x4_a2 0 -1.2363032796992138e-07
Gr5_3_2 0 s3 x5_a2 0 -1.23680890574084e-07
Gr6_3_2 0 s3 x6_a2 0 -7.958977323590569e-08
Gr7_3_2 0 s3 x7_a2 0 -2.864876055709056e-08
Gr8_3_2 0 s3 x8_a2 0 -8.365458098200733e-09
Gr9_3_2 0 s3 x9_a2 0 -4.0959378171643815e-09
Gr10_re_3_2 0 s3 x10_re_a2 0 -5.885397424866881e-10
Gr10_im_3_2 0 s3 x10_im_a2 0 2.863516618042764e-13
Gr11_3_2 0 s3 x11_a2 0 -6.323314706987973e-10
Gr12_3_2 0 s3 x12_a2 0 -1.212546630772635e-10
Gr13_3_2 0 s3 x13_a2 0 -5.581538096999956e-11
Gr14_3_2 0 s3 x14_a2 0 -2.6372689817538288e-11
Gr15_3_2 0 s3 x15_a2 0 -8.465069400152723e-12
Gr16_3_2 0 s3 x16_a2 0 -1.602085186964854e-12
Gr17_3_2 0 s3 x17_a2 0 -1.43576729287871e-13
Gr18_3_2 0 s3 x18_a2 0 -1.0187966639752085e-14
Gr19_3_2 0 s3 x19_a2 0 -3.4796888569723966e-16
Gr20_3_2 0 s3 x20_a2 0 -2.559846915831363e-18
Gr21_3_2 0 s3 x21_a2 0 -4.302408215355279e-22
Gr22_3_2 0 s3 x22_a2 0 -6.75724810488002e-30
Gr23_3_2 0 s3 x23_a2 0 -1.8431921293682585e-50
Gd3_3 0 s3 p3 0 -2.9258590145389324e-19
Fd3_3 0 s3 V3 -1.462929507269466e-17
Gr1_3_3 0 s3 x1_a3 0 -90.16784410904465
Gr2_3_3 0 s3 x2_a3 0 -0.0077453042573869015
Gr3_3_3 0 s3 x3_a3 0 -4.616938812663878e-06
Gr4_3_3 0 s3 x4_a3 0 8.728007823616254e-10
Gr5_3_3 0 s3 x5_a3 0 8.731207922393343e-10
Gr6_3_3 0 s3 x6_a3 0 5.847529585351827e-10
Gr7_3_3 0 s3 x7_a3 0 2.2370776889201366e-10
Gr8_3_3 0 s3 x8_a3 0 6.796348927985046e-11
Gr9_3_3 0 s3 x9_a3 0 3.37317979512352e-11
Gr10_re_3_3 0 s3 x10_re_a3 0 4.928689718393027e-12
Gr10_im_3_3 0 s3 x10_im_a3 0 -1.791342160725515e-13
Gr11_3_3 0 s3 x11_a3 0 5.306825783992246e-12
Gr12_3_3 0 s3 x12_a3 0 1.0245504262501092e-12
Gr13_3_3 0 s3 x13_a3 0 4.724145215654086e-13
Gr14_3_3 0 s3 x14_a3 0 2.234639945620254e-13
Gr15_3_3 0 s3 x15_a3 0 7.180327115782164e-14
Gr16_3_3 0 s3 x16_a3 0 1.3600006084356352e-14
Gr17_3_3 0 s3 x17_a3 0 1.2193286057157429e-15
Gr18_3_3 0 s3 x18_a3 0 8.653297459324062e-17
Gr19_3_3 0 s3 x19_a3 0 2.955639918997042e-18
Gr20_3_3 0 s3 x20_a3 0 2.1743458673710653e-20
Gr21_3_3 0 s3 x21_a3 0 3.654488278093101e-24
Gr22_3_3 0 s3 x22_a3 0 5.739642311681868e-32
Gr23_3_3 0 s3 x23_a3 0 1.5656171521442124e-52
Gd3_4 0 s3 p4 0 0.048725616377229705
Fd3_4 0 s3 V4 2.4362808188614857
Gr1_3_4 0 s3 x1_a4 0 8.905492677619142e+16
Gr2_3_4 0 s3 x2_a4 0 7640812008606.661
Gr3_3_4 0 s3 x3_a4 0 -4332305824.834923
Gr4_3_4 0 s3 x4_a4 0 -152558879.9623574
Gr5_3_4 0 s3 x5_a4 0 -152621264.9657419
Gr6_3_4 0 s3 x6_a4 0 -98218657.66069297
Gr7_3_4 0 s3 x7_a4 0 -35357498.16236402
Gr8_3_4 0 s3 x8_a4 0 -10325047.620943123
Gr9_3_4 0 s3 x9_a4 0 -5055511.118576535
Gr10_re_3_4 0 s3 x10_re_a4 0 -726439.1528240182
Gr10_im_3_4 0 s3 x10_im_a4 0 395.842370006248
Gr11_3_4 0 s3 x11_a4 0 -780494.3572821963
Gr12_3_4 0 s3 x12_a4 0 -149667.75330941286
Gr13_3_4 0 s3 x13_a4 0 -68894.55363304513
Gr14_3_4 0 s3 x14_a4 0 -32552.64037668082
Gr15_3_4 0 s3 x15_a4 0 -10448.719616542554
Gr16_3_4 0 s3 x16_a4 0 -1977.5101334556794
Gr17_3_4 0 s3 x17_a4 0 -177.22193366967642
Gr18_3_4 0 s3 x18_a4 0 -12.575377298112564
Gr19_3_4 0 s3 x19_a4 0 -0.4295106632163903
Gr20_3_4 0 s3 x20_a4 0 -0.003159712280212047
Gr21_3_4 0 s3 x21_a4 0 -5.31061916449784e-07
Gr22_3_4 0 s3 x22_a4 0 -8.340717451578098e-15
Gr23_3_4 0 s3 x23_a4 0 -2.275119178905186e-35
*
* State networks driven by port 3
Cx1_a3 x1_a3 0 1.0
Gx1_a3 0 x1_a3 p3 0 0.07071067811865475
Fx1_a3 0 x1_a3 V3 3.5355339059327378
Rp1_a3 0 x1_a3 1.320394725695103e-19
Cx2_a3 x2_a3 0 1.0
Gx2_a3 0 x2_a3 p3 0 0.07071067811865475
Fx2_a3 0 x2_a3 V3 3.5355339059327378
Rp2_a3 0 x2_a3 1.5371403703198e-15
Cx3_a3 x3_a3 0 1.0
Gx3_a3 0 x3_a3 p3 0 0.07071067811865475
Fx3_a3 0 x3_a3 V3 3.5355339059327378
Rp3_a3 0 x3_a3 2.5440136148156124e-12
Cx4_a3 x4_a3 0 1.0
Gx4_a3 0 x4_a3 p3 0 0.07071067811865475
Fx4_a3 0 x4_a3 V3 3.5355339059327378
Rp4_a3 0 x4_a3 1.1391706101106968e-09
Cx5_a3 x5_a3 0 1.0
Gx5_a3 0 x5_a3 p3 0 0.07071067811865475
Fx5_a3 0 x5_a3 V3 3.5355339059327378
Rp5_a3 0 x5_a3 1.138933584838299e-09
Cx6_a3 x6_a3 0 1.0
Gx6_a3 0 x6_a3 p3 0 0.07071067811865475
Fx6_a3 0 x6_a3 V3 3.5355339059327378
Rp6_a3 0 x6_a3 1.424292178555483e-09
Cx7_a3 x7_a3 0 1.0
Gx7_a3 0 x7_a3 p3 0 0.07071067811865475
Fx7_a3 0 x7_a3 V3 3.5355339059327378
Rp7_a3 0 x7_a3 2.382721558974834e-09
Cx8_a3 x8_a3 0 1.0
Gx8_a3 0 x8_a3 p3 0 0.07071067811865475
Fx8_a3 0 x8_a3 V3 3.5355339059327378
Rp8_a3 0 x8_a3 4.416030416500193e-09
Cx9_a3 x9_a3 0 1.0
Gx9_a3 0 x9_a3 p3 0 0.07071067811865475
Fx9_a3 0 x9_a3 V3 3.5355339059327378
Rp9_a3 0 x9_a3 6.3131031797856016e-09
Cx10_re_a3 x10_re_a3 0 1.0
Gx10_re_a3 0 x10_re_a3 p3 0 0.1414213562373095
Fx10_re_a3 0 x10_re_a3 V3 7.0710678118654755
Rp10_re_re_a3 0 x10_re_a3 1.3649019396502693e-08
Gp10_re_im_a3 0 x10_re_a3 x10_im_a3 0 29187174.347286176
Cx10_im_a3 x10_im_a3 0 1.0
Gp10_im_re_a3 0 x10_im_a3 x10_re_a3 0 -29187174.347286176
Rp10_im_im_a3 0 x10_im_a3 1.3649019396502693e-08
Cx11_a3 x11_a3 0 1.0
Gx11_a3 0 x11_a3 p3 0 0.07071067811865475
Fx11_a3 0 x11_a3 V3 3.5355339059327378
Rp11_a3 0 x11_a3 1.6072064937358477e-08
Cx12_a3 x12_a3 0 1.0
Gx12_a3 0 x12_a3 p3 0 0.07071067811865475
Fx12_a3 0 x12_a3 V3 3.5355339059327378
Rp12_a3 0 x12_a3 3.670436481000849e-08
Cx13_a3 x13_a3 0 1.0
Gx13_a3 0 x13_a3 p3 0 0.07071067811865475
Fx13_a3 0 x13_a3 V3 3.5355339059327378
Rp13_a3 0 x13_a3 5.4099573770772176e-08
Cx14_a3 x14_a3 0 1.0
Gx14_a3 0 x14_a3 p3 0 0.07071067811865475
Fx14_a3 0 x14_a3 V3 3.5355339059327378
Rp14_a3 0 x14_a3 7.870380105648126e-08
Cx15_a3 x15_a3 0 1.0
Gx15_a3 0 x15_a3 p3 0 0.07071067811865475
Fx15_a3 0 x15_a3 V3 3.5355339059327378
Rp15_a3 0 x15_a3 1.389182763668471e-07
Cx16_a3 x16_a3 0 1.0
Gx16_a3 0 x16_a3 p3 0 0.07071067811865475
Fx16_a3 0 x16_a3 V3 3.5355339059327378
Rp16_a3 0 x16_a3 3.1932500668354715e-07
Cx17_a3 x17_a3 0 1.0
Gx17_a3 0 x17_a3 p3 0 0.07071067811865475
Fx17_a3 0 x17_a3 V3 3.5355339059327378
Rp17_a3 0 x17_a3 1.066680172722843e-06
Cx18_a3 x18_a3 0 1.0
Gx18_a3 0 x18_a3 p3 0 0.07071067811865475
Fx18_a3 0 x18_a3 V3 3.5355339059327378
Rp18_a3 0 x18_a3 4.004355680703426e-06
Cx19_a3 x19_a3 0 1.0
Gx19_a3 0 x19_a3 p3 0 0.07071067811865475
Fx19_a3 0 x19_a3 V3 3.5355339059327378
Rp19_a3 0 x19_a3 2.16673720806938e-05
Cx20_a3 x20_a3 0 1.0
Gx20_a3 0 x20_a3 p3 0 0.07071067811865475
Fx20_a3 0 x20_a3 V3 3.5355339059327378
Rp20_a3 0 x20_a3 0.0002526210055012289
Cx21_a3 x21_a3 0 1.0
Gx21_a3 0 x21_a3 p3 0 0.07071067811865475
Fx21_a3 0 x21_a3 V3 3.5355339059327378
Rp21_a3 0 x21_a3 0.019485908117322464
Cx22_a3 x22_a3 0 1.0
Gx22_a3 0 x22_a3 p3 0 0.07071067811865475
Fx22_a3 0 x22_a3 V3 3.5355339059327378
Rp22_a3 0 x22_a3 155.48608368887304
Cx23_a3 x23_a3 0 1.0
Gx23_a3 0 x23_a3 p3 0 0.07071067811865475
Fx23_a3 0 x23_a3 V3 3.5355339059327378
Rp23_a3 0 x23_a3 2977084446687.4565
*
* Port network for port 4
V4 p4 s4 0
R4 s4 0 50.0
Gd4_1 0 s4 p1 0 2.5786636267603256e-17
Fd4_1 0 s4 V1 1.289331813380163e-15
Gr1_4_1 0 s4 x1_a1 0 194.41140189892263
Gr2_4_1 0 s4 x2_a1 0 0.01669507542786303
Gr3_4_1 0 s4 x3_a1 0 5.336372905146401e-06
Gr4_4_1 0 s4 x4_a1 0 -8.066630050934248e-08
Gr5_4_1 0 s4 x5_a1 0 -8.06992262723773e-08
Gr6_4_1 0 s4 x6_a1 0 -5.197114992064444e-08
Gr7_4_1 0 s4 x7_a1 0 -1.873066540262076e-08
Gr8_4_1 0 s4 x8_a1 0 -5.474035409409436e-09
Gr9_4_1 0 s4 x9_a1 0 -2.681029473858552e-09
Gr10_re_4_1 0 s4 x10_re_a1 0 -3.853781096446363e-10
Gr10_im_4_1 0 s4 x10_im_a1 0 4.999289635436529e-13
Gr11_4_1 0 s4 x11_a1 0 -4.1407326444169534e-10
Gr12_4_1 0 s4 x12_a1 0 -7.941412989387612e-11
Gr13_4_1 0 s4 x13_a1 0 -3.6556952981350567e-11
Gr14_4_1 0 s4 x14_a1 0 -1.7273549198066238e-11
Gr15_4_1 0 s4 x15_a1 0 -5.5445744039878605e-12
Gr16_4_1 0 s4 x16_a1 0 -1.049375884065524e-12
Gr17_4_1 0 s4 x17_a1 0 -9.404457073162869e-14
Gr18_4_1 0 s4 x18_a1 0 -6.673267020381904e-15
Gr19_4_1 0 s4 x19_a1 0 -2.279249092404841e-16
Gr20_4_1 0 s4 x20_a1 0 -1.6767389511027637e-18
Gr21_4_1 0 s4 x21_a1 0 -2.8181433498216794e-22
Gr22_4_1 0 s4 x22_a1 0 -4.426101118486097e-30
Gr23_4_1 0 s4 x23_a1 0 -1.2073191066478834e-50
Gd4_2 0 s4 p2 0 0.27633092313770735
Fd4_2 0 s4 V2 13.816546156885368
Gr1_4_2 0 s4 x1_a2 0 5.051382478361246e+17
Gr2_4_2 0 s4 x2_a2 0 43340299788812.99
Gr3_4_2 0 s4 x3_a2 0 -24564384505.194836
Gr4_4_2 0 s4 x4_a2 0 -865186262.8723525
Gr5_4_2 0 s4 x5_a2 0 -865540058.351816
Gr6_4_2 0 s4 x6_a2 0 -557014032.9441202
Gr7_4_2 0 s4 x7_a2 0 -200518154.73887444
Gr8_4_2 0 s4 x8_a2 0 -58555036.44502276
Gr9_4_2 0 s4 x9_a2 0 -28670632.1892595
Gr10_re_4_2 0 s4 x10_re_a2 0 -4119755.5893904692
Gr10_im_4_2 0 s4 x10_im_a2 0 2245.0705239032627
Gr11_4_2 0 s4 x11_a2 0 -4426311.532086171
Gr12_4_2 0 s4 x12_a2 0 -848790.3876370775
Gr13_4_2 0 s4 x13_a2 0 -390712.31922241463
Gr14_4_2 0 s4 x14_a2 0 -184611.36571009282
Gr15_4_2 0 s4 x15_a2 0 -59256.403738176574
Gr16_4_2 0 s4 x16_a2 0 -11214.784517163429
Gr17_4_2 0 s4 x17_a2 0 -1005.0546721615365
Gr18_4_2 0 s4 x18_a2 0 -71.31702858701861
Gr19_4_2 0 s4 x19_a2 0 -2.435825464508335
Gr20_4_2 0 s4 x20_a2 0 -0.017919246928827202
Gr21_4_2 0 s4 x21_a2 0 -3.0117392887210145e-06
Gr22_4_2 0 s4 x22_a2 0 -4.7301577588108544e-14
Gr23_4_2 0 s4 x23_a2 0 -1.2902574267494934e-34
Gd4_3 0 s4 p3 0 0.04872561637723
Fd4_3 0 s4 V3 2.4362808188615
Gr1_4_3 0 s4 x1_a3 0 8.905492677619184e+16
Gr2_4_3 0 s4 x2_a3 0 7640812008606.706
Gr3_4_3 0 s4 x3_a3 0 -4332305824.834951
Gr4_4_3 0 s4 x4_a3 0 -152558879.96235827
Gr5_4_3 0 s4 x5_a3 0 -152621264.96574277
Gr6_4_3 0 s4 x6_a3 0 -98218657.66069356
Gr7_4_3 0 s4 x7_a3 0 -35357498.16236424
Gr8_4_3 0 s4 x8_a3 0 -10325047.620943185
Gr9_4_3 0 s4 x9_a3 0 -5055511.118576564
Gr10_re_4_3 0 s4 x10_re_a3 0 -726439.1528240223
Gr10_im_4_3 0 s4 x10_im_a3 0 395.84237000625006
Gr11_4_3 0 s4 x11_a3 0 -780494.3572822007
Gr12_4_3 0 s4 x12_a3 0 -149667.7533094137
Gr13_4_3 0 s4 x13_a3 0 -68894.55363304554
Gr14_4_3 0 s4 x14_a3 0 -32552.640376681018
Gr15_4_3 0 s4 x15_a3 0 -10448.719616542618
Gr16_4_3 0 s4 x16_a3 0 -1977.5101334556912
Gr17_4_3 0 s4 x17_a3 0 -177.22193366967744
Gr18_4_3 0 s4 x18_a3 0 -12.575377298112635
Gr19_4_3 0 s4 x19_a3 0 -0.42951066321639275
Gr20_4_3 0 s4 x20_a3 0 -0.0031597122802120656
Gr21_4_3 0 s4 x21_a3 0 -5.310619164497872e-07
Gr22_4_3 0 s4 x22_a3 0 -8.340717451578147e-15
Gr23_4_3 0 s4 x23_a3 0 -2.2751191789051996e-35
Gd4_4 0 s4 p4 0 6.288241569747149e-17
Fd4_4 0 s4 V4 3.1441207848735745e-15
Gr1_4_4 0 s4 x1_a4 0 -2.622070567802514
Gr2_4_4 0 s4 x2_a4 0 -0.000236780740839182
Gr3_4_4 0 s4 x3_a4 0 -1.1680113882118564e-05
Gr4_4_4 0 s4 x4_a4 0 -1.9694028065404626e-07
Gr5_4_4 0 s4 x5_a4 0 -1.9702086267443162e-07
Gr6_4_4 0 s4 x6_a4 0 -1.2676181768592557e-07
Gr7_4_4 0 s4 x7_a4 0 -4.5615365039445764e-08
Gr8_4_4 0 s4 x8_a4 0 -1.3317077796340961e-08
Gr9_4_4 0 s4 x9_a4 0 -6.519919674868002e-09
Gr10_re_4_4 0 s4 x10_re_a4 0 -9.367565902673267e-10
Gr10_im_4_4 0 s4 x10_im_a4 0 2.7903899697369457e-13
Gr11_4_4 0 s4 x11_a4 0 -1.0064468333875413e-09
Gr12_4_4 0 s4 x12_a4 0 -1.9298737962122605e-10
Gr13_4_4 0 s4 x13_a4 0 -8.883425223668241e-11
Gr14_4_4 0 s4 x14_a4 0 -4.197381174058818e-11
Gr15_4_4 0 s4 x15_a4 0 -1.3472619768993396e-11
Gr16_4_4 0 s4 x16_a4 0 -2.549795341651393e-12
Gr17_4_4 0 s4 x17_a4 0 -2.2850873011062624e-13
Gr18_4_4 0 s4 x18_a4 0 -1.6214589150319353e-14
Gr19_4_4 0 s4 x19_a4 0 -5.538074024027124e-16
Gr20_4_4 0 s4 x20_a4 0 -4.074105955794269e-18
Gr21_4_4 0 s4 x21_a4 0 -6.847466837092572e-22
Gr22_4_4 0 s4 x22_a4 0 -1.0754449598854826e-29
Gr23_4_4 0 s4 x23_a4 0 -2.9335191706193338e-50
*
* State networks driven by port 4
Cx1_a4 x1_a4 0 1.0
Gx1_a4 0 x1_a4 p4 0 0.07071067811865475
Fx1_a4 0 x1_a4 V4 3.5355339059327378
Rp1_a4 0 x1_a4 1.320394725695103e-19
Cx2_a4 x2_a4 0 1.0
Gx2_a4 0 x2_a4 p4 0 0.07071067811865475
Fx2_a4 0 x2_a4 V4 3.5355339059327378
Rp2_a4 0 x2_a4 1.5371403703198e-15
Cx3_a4 x3_a4 0 1.0
Gx3_a4 0 x3_a4 p4 0 0.07071067811865475
Fx3_a4 0 x3_a4 V4 3.5355339059327378
Rp3_a4 0 x3_a4 2.5440136148156124e-12
Cx4_a4 x4_a4 0 1.0
Gx4_a4 0 x4_a4 p4 0 0.07071067811865475
Fx4_a4 0 x4_a4 V4 3.5355339059327378
Rp4_a4 0 x4_a4 1.1391706101106968e-09
Cx5_a4 x5_a4 0 1.0
Gx5_a4 0 x5_a4 p4 0 0.07071067811865475
Fx5_a4 0 x5_a4 V4 3.5355339059327378
Rp5_a4 0 x5_a4 1.138933584838299e-09
Cx6_a4 x6_a4 0 1.0
Gx6_a4 0 x6_a4 p4 0 0.07071067811865475
Fx6_a4 0 x6_a4 V4 3.5355339059327378
Rp6_a4 0 x6_a4 1.424292178555483e-09
Cx7_a4 x7_a4 0 1.0
Gx7_a4 0 x7_a4 p4 0 0.07071067811865475
Fx7_a4 0 x7_a4 V4 3.5355339059327378
Rp7_a4 0 x7_a4 2.382721558974834e-09
Cx8_a4 x8_a4 0 1.0
Gx8_a4 0 x8_a4 p4 0 0.07071067811865475
Fx8_a4 0 x8_a4 V4 3.5355339059327378
Rp8_a4 0 x8_a4 4.416030416500193e-09
Cx9_a4 x9_a4 0 1.0
Gx9_a4 0 x9_a4 p4 0 0.07071067811865475
Fx9_a4 0 x9_a4 V4 3.5355339059327378
Rp9_a4 0 x9_a4 6.3131031797856016e-09
Cx10_re_a4 x10_re_a4 0 1.0
Gx10_re_a4 0 x10_re_a4 p4 0 0.1414213562373095
Fx10_re_a4 0 x10_re_a4 V4 7.0710678118654755
Rp10_re_re_a4 0 x10_re_a4 1.3649019396502693e-08
Gp10_re_im_a4 0 x10_re_a4 x10_im_a4 0 29187174.347286176
Cx10_im_a4 x10_im_a4 0 1.0
Gp10_im_re_a4 0 x10_im_a4 x10_re_a4 0 -29187174.347286176
Rp10_im_im_a4 0 x10_im_a4 1.3649019396502693e-08
Cx11_a4 x11_a4 0 1.0
Gx11_a4 0 x11_a4 p4 0 0.07071067811865475
Fx11_a4 0 x11_a4 V4 3.5355339059327378
Rp11_a4 0 x11_a4 1.6072064937358477e-08
Cx12_a4 x12_a4 0 1.0
Gx12_a4 0 x12_a4 p4 0 0.07071067811865475
Fx12_a4 0 x12_a4 V4 3.5355339059327378
Rp12_a4 0 x12_a4 3.670436481000849e-08
Cx13_a4 x13_a4 0 1.0
Gx13_a4 0 x13_a4 p4 0 0.07071067811865475
Fx13_a4 0 x13_a4 V4 3.5355339059327378
Rp13_a4 0 x13_a4 5.4099573770772176e-08
Cx14_a4 x14_a4 0 1.0
Gx14_a4 0 x14_a4 p4 0 0.07071067811865475
Fx14_a4 0 x14_a4 V4 3.5355339059327378
Rp14_a4 0 x14_a4 7.870380105648126e-08
Cx15_a4 x15_a4 0 1.0
Gx15_a4 0 x15_a4 p4 0 0.07071067811865475
Fx15_a4 0 x15_a4 V4 3.5355339059327378
Rp15_a4 0 x15_a4 1.389182763668471e-07
Cx16_a4 x16_a4 0 1.0
Gx16_a4 0 x16_a4 p4 0 0.07071067811865475
Fx16_a4 0 x16_a4 V4 3.5355339059327378
Rp16_a4 0 x16_a4 3.1932500668354715e-07
Cx17_a4 x17_a4 0 1.0
Gx17_a4 0 x17_a4 p4 0 0.07071067811865475
Fx17_a4 0 x17_a4 V4 3.5355339059327378
Rp17_a4 0 x17_a4 1.066680172722843e-06
Cx18_a4 x18_a4 0 1.0
Gx18_a4 0 x18_a4 p4 0 0.07071067811865475
Fx18_a4 0 x18_a4 V4 3.5355339059327378
Rp18_a4 0 x18_a4 4.004355680703426e-06
Cx19_a4 x19_a4 0 1.0
Gx19_a4 0 x19_a4 p4 0 0.07071067811865475
Fx19_a4 0 x19_a4 V4 3.5355339059327378
Rp19_a4 0 x19_a4 2.16673720806938e-05
Cx20_a4 x20_a4 0 1.0
Gx20_a4 0 x20_a4 p4 0 0.07071067811865475
Fx20_a4 0 x20_a4 V4 3.5355339059327378
Rp20_a4 0 x20_a4 0.0002526210055012289
Cx21_a4 x21_a4 0 1.0
Gx21_a4 0 x21_a4 p4 0 0.07071067811865475
Fx21_a4 0 x21_a4 V4 3.5355339059327378
Rp21_a4 0 x21_a4 0.019485908117322464
Cx22_a4 x22_a4 0 1.0
Gx22_a4 0 x22_a4 p4 0 0.07071067811865475
Fx22_a4 0 x22_a4 V4 3.5355339059327378
Rp22_a4 0 x22_a4 155.48608368887304
Cx23_a4 x23_a4 0 1.0
Gx23_a4 0 x23_a4 p4 0 0.07071067811865475
Fx23_a4 0 x23_a4 V4 3.5355339059327378
Rp23_a4 0 x23_a4 2977084446687.4565
.ENDS s_equivalent
