* EQUIVALENT CIRCUIT FOR VECTOR FITTED S-MATRIX
* Created using scikit-rf vectorFitting.py
*
.SUBCKT s_equivalent p1 p2
*
* Port network for port 1
V1 p1 s1 0
R1 s1 0 50.0
Gd1_1 0 s1 p1 0 -0.005352043165156799
Fd1_1 0 s1 V1 -0.26760215825783995
Gr1_1_1 0 s1 x1_a1 0 -2.0731171270483627e+30
Gr2_1_1 0 s1 x2_a1 0 -2.2370874369046445e+17
Gr3_1_1 0 s1 x3_a1 0 -1237308062835.4058
Gr4_1_1 0 s1 x4_a1 0 -1245048180.738943
Gr5_1_1 0 s1 x5_a1 0 -9120906.80673365
Gr6_1_1 0 s1 x6_a1 0 -2046.0483669795083
Gr7_1_1 0 s1 x7_a1 0 10.069115435173513
Gr8_re_1_1 0 s1 x8_re_a1 0 1.217388004250737e-08
Gr8_im_1_1 0 s1 x8_im_a1 0 1.0499646686179012e-07
Gr9_re_1_1 0 s1 x9_re_a1 0 1.508900981946968e-06
Gr9_im_1_1 0 s1 x9_im_a1 0 -6.954998991643249e-06
Gr10_re_1_1 0 s1 x10_re_a1 0 -3.7573484338466952e-06
Gr10_im_1_1 0 s1 x10_im_a1 0 7.55561664721333e-06
Gr11_1_1 0 s1 x11_a1 0 6.670158954861853e-10
Gr12_1_1 0 s1 x12_a1 0 5.306552242247331e-12
Gr13_1_1 0 s1 x13_a1 0 5.4140856911770124e-14
Gr14_1_1 0 s1 x14_a1 0 3.479451173263462e-16
Gr15_1_1 0 s1 x15_a1 0 9.043327268678593e-19
Gr16_1_1 0 s1 x16_a1 0 4.290009977295791e-22
Gr17_1_1 0 s1 x17_a1 0 3.1472576336962295e-26
Gr18_1_1 0 s1 x18_a1 0 1.1608794137708267e-33
Gr19_1_1 0 s1 x19_a1 0 3.313039914480059e-40
Gr20_1_1 0 s1 x20_a1 0 1.8407442244181527e-46
Gr21_1_1 0 s1 x21_a1 0 3.704421669471399e-49
Gd1_2 0 s1 p2 0 -0.00606440888531685
Fd1_2 0 s1 V2 -0.3032204442658425
Gr1_1_2 0 s1 x1_a2 0 1.2380470688375523e+31
Gr2_1_2 0 s1 x2_a2 0 1.3359686762785152e+18
Gr3_1_2 0 s1 x3_a2 0 7389093459798.206
Gr4_1_2 0 s1 x4_a2 0 7435316968.000218
Gr5_1_2 0 s1 x5_a2 0 54469456.66480477
Gr6_1_2 0 s1 x6_a2 0 12433.045627818308
Gr7_1_2 0 s1 x7_a2 0 11.32401798629966
Gr8_re_1_2 0 s1 x8_re_a2 0 1.377493156503156e-08
Gr8_im_1_2 0 s1 x8_im_a2 0 1.1872743969428055e-07
Gr9_re_1_2 0 s1 x9_re_a2 0 1.690058935194465e-06
Gr9_im_1_2 0 s1 x9_im_a2 0 -7.867291818090428e-06
Gr10_re_1_2 0 s1 x10_re_a2 0 -4.218840194756334e-06
Gr10_im_1_2 0 s1 x10_im_a2 0 8.56315396642999e-06
Gr11_1_2 0 s1 x11_a2 0 7.008783830098377e-10
Gr12_1_2 0 s1 x12_a2 0 5.575960371766682e-12
Gr13_1_2 0 s1 x13_a2 0 5.688954049821211e-14
Gr14_1_2 0 s1 x14_a2 0 3.656099900239928e-16
Gr15_1_2 0 s1 x15_a2 0 9.502449185674599e-19
Gr16_1_2 0 s1 x16_a2 0 4.507810079955306e-22
Gr17_1_2 0 s1 x17_a2 0 3.3070411865001164e-26
Gr18_1_2 0 s1 x18_a2 0 1.2198162593354533e-33
Gr19_1_2 0 s1 x19_a2 0 3.4812400905473572e-40
Gr20_1_2 0 s1 x20_a2 0 1.9341972194420855e-46
Gr21_1_2 0 s1 x21_a2 0 3.8924919593309735e-49
*
* State networks driven by port 1
Cx1_a1 x1_a1 0 1.0
Gx1_a1 0 x1_a1 p1 0 0.07071067811865475
Fx1_a1 0 x1_a1 V1 3.5355339059327378
Rp1_a1 0 x1_a1 2.898363497775357e-33
Cx2_a1 x2_a1 0 1.0
Gx2_a1 0 x2_a1 p1 0 0.07071067811865475
Fx2_a1 0 x2_a1 V1 3.5355339059327378
Rp2_a1 0 x2_a1 2.6859240763355072e-20
Cx3_a1 x3_a1 0 1.0
Gx3_a1 0 x3_a1 p1 0 0.07071067811865475
Fx3_a1 0 x3_a1 V1 3.5355339059327378
Rp3_a1 0 x3_a1 4.856225533462878e-15
Cx4_a1 x4_a1 0 1.0
Gx4_a1 0 x4_a1 p1 0 0.07071067811865475
Fx4_a1 0 x4_a1 V1 3.5355339059327378
Rp4_a1 0 x4_a1 4.826035612486342e-12
Cx5_a1 x5_a1 0 1.0
Gx5_a1 0 x5_a1 p1 0 0.07071067811865475
Fx5_a1 0 x5_a1 V1 3.5355339059327378
Rp5_a1 0 x5_a1 6.58775153927215e-10
Cx6_a1 x6_a1 0 1.0
Gx6_a1 0 x6_a1 p1 0 0.07071067811865475
Fx6_a1 0 x6_a1 V1 3.5355339059327378
Rp6_a1 0 x6_a1 2.893302388929048e-06
Cx7_a1 x7_a1 0 1.0
Gx7_a1 0 x7_a1 p1 0 0.07071067811865475
Fx7_a1 0 x7_a1 V1 3.5355339059327378
Rp7_a1 0 x7_a1 0.011700570630848065
Cx8_re_a1 x8_re_a1 0 1.0
Gx8_re_a1 0 x8_re_a1 p1 0 0.1414213562373095
Fx8_re_a1 0 x8_re_a1 V1 7.0710678118654755
Rp8_re_re_a1 0 x8_re_a1 13611223.027980324
Gp8_re_im_a1 0 x8_re_a1 x8_im_a1 0 62.83185586334878
Cx8_im_a1 x8_im_a1 0 1.0
Gp8_im_re_a1 0 x8_im_a1 x8_re_a1 0 -62.83185586334878
Rp8_im_im_a1 0 x8_im_a1 13611223.027980324
Cx9_re_a1 x9_re_a1 0 1.0
Gx9_re_a1 0 x9_re_a1 p1 0 0.1414213562373095
Fx9_re_a1 0 x9_re_a1 V1 7.0710678118654755
Rp9_re_re_a1 0 x9_re_a1 2303081.7076267432
Gp9_re_im_a1 0 x9_re_a1 x9_im_a1 0 25.13263875344495
Cx9_im_a1 x9_im_a1 0 1.0
Gp9_im_re_a1 0 x9_im_a1 x9_re_a1 0 -25.13263875344495
Rp9_im_im_a1 0 x9_im_a1 2303081.7076267432
Cx10_re_a1 x10_re_a1 0 1.0
Gx10_re_a1 0 x10_re_a1 p1 0 0.1414213562373095
Fx10_re_a1 0 x10_re_a1 V1 7.0710678118654755
Rp10_re_re_a1 0 x10_re_a1 292105.52674955386
Gp10_re_im_a1 0 x10_re_a1 x10_im_a1 0 6.283287537672271
Cx10_im_a1 x10_im_a1 0 1.0
Gp10_im_re_a1 0 x10_im_a1 x10_re_a1 0 -6.283287537672271
Rp10_im_im_a1 0 x10_im_a1 292105.52674955386
Cx11_a1 x11_a1 0 1.0
Gx11_a1 0 x11_a1 p1 0 0.07071067811865475
Fx11_a1 0 x11_a1 V1 3.5355339059327378
Rp11_a1 0 x11_a1 4846.1002753792
Cx12_a1 x12_a1 0 1.0
Gx12_a1 0 x12_a1 p1 0 0.07071067811865475
Fx12_a1 0 x12_a1 V1 3.5355339059327378
Rp12_a1 0 x12_a1 54332.4762866556
Cx13_a1 x13_a1 0 1.0
Gx13_a1 0 x13_a1 p1 0 0.07071067811865475
Fx13_a1 0 x13_a1 V1 3.5355339059327378
Rp13_a1 0 x13_a1 537902.5699719464
Cx14_a1 x14_a1 0 1.0
Gx14_a1 0 x14_a1 p1 0 0.07071067811865475
Fx14_a1 0 x14_a1 V1 3.5355339059327378
Rp14_a1 0 x14_a1 6709819.790846151
Cx15_a1 x15_a1 0 1.0
Gx15_a1 0 x15_a1 p1 0 0.07071067811865475
Fx15_a1 0 x15_a1 V1 3.5355339059327378
Rp15_a1 0 x15_a1 131614006.41401666
Cx16_a1 x16_a1 0 1.0
Gx16_a1 0 x16_a1 p1 0 0.07071067811865475
Fx16_a1 0 x16_a1 V1 3.5355339059327378
Rp16_a1 0 x16_a1 6042784165.528305
Cx17_a1 x17_a1 0 1.0
Gx17_a1 0 x17_a1 p1 0 0.07071067811865475
Fx17_a1 0 x17_a1 V1 3.5355339059327378
Rp17_a1 0 x17_a1 705504983485.8875
Cx18_a1 x18_a1 0 1.0
Gx18_a1 0 x18_a1 p1 0 0.07071067811865475
Fx18_a1 0 x18_a1 V1 3.5355339059327378
Rp18_a1 0 x18_a1 3673437699619968.5
Cx19_a1 x19_a1 0 1.0
Gx19_a1 0 x19_a1 p1 0 0.07071067811865475
Fx19_a1 0 x19_a1 V1 3.5355339059327378
Rp19_a1 0 x19_a1 6.8762696584268e+18
Cx20_a1 x20_a1 0 1.0
Gx20_a1 0 x20_a1 p1 0 0.07071067811865475
Fx20_a1 0 x20_a1 V1 3.5355339059327378
Rp20_a1 0 x20_a1 9.22506660369187e+21
Cx21_a1 x21_a1 0 1.0
Gx21_a1 0 x21_a1 p1 0 0.07071067811865475
Fx21_a1 0 x21_a1 V1 3.5355339059327378
Rp21_a1 0 x21_a1 2.056392568097956e+23
*
* Port network for port 2
V2 p2 s2 0
R2 s2 0 50.0
Gd2_1 0 s2 p1 0 -0.00606440888531685
Fd2_1 0 s2 V1 -0.3032204442658425
Gr1_2_1 0 s2 x1_a1 0 1.2380470688375523e+31
Gr2_2_1 0 s2 x2_a1 0 1.3359686762785152e+18
Gr3_2_1 0 s2 x3_a1 0 7389093459798.206
Gr4_2_1 0 s2 x4_a1 0 7435316968.000218
Gr5_2_1 0 s2 x5_a1 0 54469456.66480477
Gr6_2_1 0 s2 x6_a1 0 12433.045627818308
Gr7_2_1 0 s2 x7_a1 0 11.32401798629966
Gr8_re_2_1 0 s2 x8_re_a1 0 1.377493156503156e-08
Gr8_im_2_1 0 s2 x8_im_a1 0 1.1872743969428055e-07
Gr9_re_2_1 0 s2 x9_re_a1 0 1.690058935194465e-06
Gr9_im_2_1 0 s2 x9_im_a1 0 -7.867291818090428e-06
Gr10_re_2_1 0 s2 x10_re_a1 0 -4.218840194756334e-06
Gr10_im_2_1 0 s2 x10_im_a1 0 8.56315396642999e-06
Gr11_2_1 0 s2 x11_a1 0 7.008783830098377e-10
Gr12_2_1 0 s2 x12_a1 0 5.575960371766682e-12
Gr13_2_1 0 s2 x13_a1 0 5.688954049821211e-14
Gr14_2_1 0 s2 x14_a1 0 3.656099900239928e-16
Gr15_2_1 0 s2 x15_a1 0 9.502449185674599e-19
Gr16_2_1 0 s2 x16_a1 0 4.507810079955306e-22
Gr17_2_1 0 s2 x17_a1 0 3.3070411865001164e-26
Gr18_2_1 0 s2 x18_a1 0 1.2198162593354533e-33
Gr19_2_1 0 s2 x19_a1 0 3.4812400905473572e-40
Gr20_2_1 0 s2 x20_a1 0 1.9341972194420855e-46
Gr21_2_1 0 s2 x21_a1 0 3.8924919593309735e-49
Gd2_2 0 s2 p2 0 -0.004239607540889642
Fd2_2 0 s2 V2 -0.21198037704448214
Gr1_2_2 0 s2 x1_a2 0 -1.599011384140978e+30
Gr2_2_2 0 s2 x2_a2 0 -1.7254829610241462e+17
Gr3_2_2 0 s2 x3_a2 0 -954345344191.1243
Gr4_2_2 0 s2 x4_a2 0 -960315356.563435
Gr5_2_2 0 s2 x5_a2 0 -7035025.605163758
Gr6_2_2 0 s2 x6_a2 0 -1577.2906853366246
Gr7_2_2 0 s2 x7_a2 0 8.062183370112464
Gr8_re_2_2 0 s2 x8_re_a2 0 9.623946354421379e-09
Gr8_im_2_2 0 s2 x8_im_a2 0 8.341935463906612e-08
Gr9_re_2_2 0 s2 x9_re_a2 0 1.2174682178849243e-06
Gr9_im_2_2 0 s2 x9_im_a2 0 -5.522989927066453e-06
Gr10_re_2_2 0 s2 x10_re_a2 0 -3.0181813256976253e-06
Gr10_im_2_2 0 s2 x10_im_a2 0 5.983206147993047e-06
Gr11_2_2 0 s2 x11_a2 0 5.342289709794514e-10
Gr12_2_2 0 s2 x12_a2 0 4.2501433865953235e-12
Gr13_2_2 0 s2 x13_a2 0 4.336269372405813e-14
Gr14_2_2 0 s2 x14_a2 0 2.786774790769572e-16
Gr15_2_2 0 s2 x15_a2 0 7.243014831100178e-19
Gr16_2_2 0 s2 x16_a2 0 3.4359705192155172e-22
Gr17_2_2 0 s2 x17_a2 0 2.5207131225765312e-26
Gr18_2_2 0 s2 x18_a2 0 9.29775796137923e-34
Gr19_2_2 0 s2 x19_a2 0 2.6534920746992615e-40
Gr20_2_2 0 s2 x20_a2 0 1.474295612828001e-46
Gr21_2_2 0 s2 x21_a2 0 2.9669589848057136e-49
*
* State networks driven by port 2
Cx1_a2 x1_a2 0 1.0
Gx1_a2 0 x1_a2 p2 0 0.07071067811865475
Fx1_a2 0 x1_a2 V2 3.5355339059327378
Rp1_a2 0 x1_a2 2.898363497775357e-33
Cx2_a2 x2_a2 0 1.0
Gx2_a2 0 x2_a2 p2 0 0.07071067811865475
Fx2_a2 0 x2_a2 V2 3.5355339059327378
Rp2_a2 0 x2_a2 2.6859240763355072e-20
Cx3_a2 x3_a2 0 1.0
Gx3_a2 0 x3_a2 p2 0 0.07071067811865475
Fx3_a2 0 x3_a2 V2 3.5355339059327378
Rp3_a2 0 x3_a2 4.856225533462878e-15
Cx4_a2 x4_a2 0 1.0
Gx4_a2 0 x4_a2 p2 0 0.07071067811865475
Fx4_a2 0 x4_a2 V2 3.5355339059327378
Rp4_a2 0 x4_a2 4.826035612486342e-12
Cx5_a2 x5_a2 0 1.0
Gx5_a2 0 x5_a2 p2 0 0.07071067811865475
Fx5_a2 0 x5_a2 V2 3.5355339059327378
Rp5_a2 0 x5_a2 6.58775153927215e-10
Cx6_a2 x6_a2 0 1.0
Gx6_a2 0 x6_a2 p2 0 0.07071067811865475
Fx6_a2 0 x6_a2 V2 3.5355339059327378
Rp6_a2 0 x6_a2 2.893302388929048e-06
Cx7_a2 x7_a2 0 1.0
Gx7_a2 0 x7_a2 p2 0 0.07071067811865475
Fx7_a2 0 x7_a2 V2 3.5355339059327378
Rp7_a2 0 x7_a2 0.011700570630848065
Cx8_re_a2 x8_re_a2 0 1.0
Gx8_re_a2 0 x8_re_a2 p2 0 0.1414213562373095
Fx8_re_a2 0 x8_re_a2 V2 7.0710678118654755
Rp8_re_re_a2 0 x8_re_a2 13611223.027980324
Gp8_re_im_a2 0 x8_re_a2 x8_im_a2 0 62.83185586334878
Cx8_im_a2 x8_im_a2 0 1.0
Gp8_im_re_a2 0 x8_im_a2 x8_re_a2 0 -62.83185586334878
Rp8_im_im_a2 0 x8_im_a2 13611223.027980324
Cx9_re_a2 x9_re_a2 0 1.0
Gx9_re_a2 0 x9_re_a2 p2 0 0.1414213562373095
Fx9_re_a2 0 x9_re_a2 V2 7.0710678118654755
Rp9_re_re_a2 0 x9_re_a2 2303081.7076267432
Gp9_re_im_a2 0 x9_re_a2 x9_im_a2 0 25.13263875344495
Cx9_im_a2 x9_im_a2 0 1.0
Gp9_im_re_a2 0 x9_im_a2 x9_re_a2 0 -25.13263875344495
Rp9_im_im_a2 0 x9_im_a2 2303081.7076267432
Cx10_re_a2 x10_re_a2 0 1.0
Gx10_re_a2 0 x10_re_a2 p2 0 0.1414213562373095
Fx10_re_a2 0 x10_re_a2 V2 7.0710678118654755
Rp10_re_re_a2 0 x10_re_a2 292105.52674955386
Gp10_re_im_a2 0 x10_re_a2 x10_im_a2 0 6.283287537672271
Cx10_im_a2 x10_im_a2 0 1.0
Gp10_im_re_a2 0 x10_im_a2 x10_re_a2 0 -6.283287537672271
Rp10_im_im_a2 0 x10_im_a2 292105.52674955386
Cx11_a2 x11_a2 0 1.0
Gx11_a2 0 x11_a2 p2 0 0.07071067811865475
Fx11_a2 0 x11_a2 V2 3.5355339059327378
Rp11_a2 0 x11_a2 4846.1002753792
Cx12_a2 x12_a2 0 1.0
Gx12_a2 0 x12_a2 p2 0 0.07071067811865475
Fx12_a2 0 x12_a2 V2 3.5355339059327378
Rp12_a2 0 x12_a2 54332.4762866556
Cx13_a2 x13_a2 0 1.0
Gx13_a2 0 x13_a2 p2 0 0.07071067811865475
Fx13_a2 0 x13_a2 V2 3.5355339059327378
Rp13_a2 0 x13_a2 537902.5699719464
Cx14_a2 x14_a2 0 1.0
Gx14_a2 0 x14_a2 p2 0 0.07071067811865475
Fx14_a2 0 x14_a2 V2 3.5355339059327378
Rp14_a2 0 x14_a2 6709819.790846151
Cx15_a2 x15_a2 0 1.0
Gx15_a2 0 x15_a2 p2 0 0.07071067811865475
Fx15_a2 0 x15_a2 V2 3.5355339059327378
Rp15_a2 0 x15_a2 131614006.41401666
Cx16_a2 x16_a2 0 1.0
Gx16_a2 0 x16_a2 p2 0 0.07071067811865475
Fx16_a2 0 x16_a2 V2 3.5355339059327378
Rp16_a2 0 x16_a2 6042784165.528305
Cx17_a2 x17_a2 0 1.0
Gx17_a2 0 x17_a2 p2 0 0.07071067811865475
Fx17_a2 0 x17_a2 V2 3.5355339059327378
Rp17_a2 0 x17_a2 705504983485.8875
Cx18_a2 x18_a2 0 1.0
Gx18_a2 0 x18_a2 p2 0 0.07071067811865475
Fx18_a2 0 x18_a2 V2 3.5355339059327378
Rp18_a2 0 x18_a2 3673437699619968.5
Cx19_a2 x19_a2 0 1.0
Gx19_a2 0 x19_a2 p2 0 0.07071067811865475
Fx19_a2 0 x19_a2 V2 3.5355339059327378
Rp19_a2 0 x19_a2 6.8762696584268e+18
Cx20_a2 x20_a2 0 1.0
Gx20_a2 0 x20_a2 p2 0 0.07071067811865475
Fx20_a2 0 x20_a2 V2 3.5355339059327378
Rp20_a2 0 x20_a2 9.22506660369187e+21
Cx21_a2 x21_a2 0 1.0
Gx21_a2 0 x21_a2 p2 0 0.07071067811865475
Fx21_a2 0 x21_a2 V2 3.5355339059327378
Rp21_a2 0 x21_a2 2.056392568097956e+23
.ENDS s_equivalent
