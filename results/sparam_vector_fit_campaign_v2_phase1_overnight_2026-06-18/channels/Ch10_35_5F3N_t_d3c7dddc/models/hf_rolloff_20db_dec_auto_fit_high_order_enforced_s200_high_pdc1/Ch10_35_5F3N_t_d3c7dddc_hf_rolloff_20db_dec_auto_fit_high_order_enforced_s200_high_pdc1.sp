* EQUIVALENT CIRCUIT FOR VECTOR FITTED S-MATRIX
* Created using scikit-rf vectorFitting.py
*
.SUBCKT s_equivalent p1 p2 p3 p4
*
* Port network for port 1
V1 p1 s1 0
R1 s1 0 50.0
Gd1_1 0 s1 p1 0 -0.0006592415790777028
Fd1_1 0 s1 V1 -0.03296207895388514
Gr1_re_1_1 0 s1 x1_re_a1 0 -27717715827.708935
Gr1_im_1_1 0 s1 x1_im_a1 0 37341511328.44753
Gr2_re_1_1 0 s1 x2_re_a1 0 -4979510138731103.0
Gr2_im_1_1 0 s1 x2_im_a1 0 3880868539861558.0
Gr3_re_1_1 0 s1 x3_re_a1 0 5.863597559022975e+16
Gr3_im_1_1 0 s1 x3_im_a1 0 4.74545516073824e+16
Gr4_re_1_1 0 s1 x4_re_a1 0 -8.468331371088896e+16
Gr4_im_1_1 0 s1 x4_im_a1 0 -1.9698551367347894e+17
Gr5_re_1_1 0 s1 x5_re_a1 0 -9.457233942149283e+17
Gr5_im_1_1 0 s1 x5_im_a1 0 1.5502425221982403e+17
Gr6_re_1_1 0 s1 x6_re_a1 0 -7.234611069808805e+16
Gr6_im_1_1 0 s1 x6_im_a1 0 -9.707151007646464e+17
Gr7_re_1_1 0 s1 x7_re_a1 0 -9.12737083231998e+17
Gr7_im_1_1 0 s1 x7_im_a1 0 2.423542626897959e+18
Gr8_re_1_1 0 s1 x8_re_a1 0 -2.1172713029341604e+18
Gr8_im_1_1 0 s1 x8_im_a1 0 1.9410622118897364e+18
Gr9_re_1_1 0 s1 x9_re_a1 0 5.624166588752739e+18
Gr9_im_1_1 0 s1 x9_im_a1 0 3.373013356535766e+17
Gr10_re_1_1 0 s1 x10_re_a1 0 6.830492142460707e+19
Gr10_im_1_1 0 s1 x10_im_a1 0 2.238984703186707e+19
Gr11_re_1_1 0 s1 x11_re_a1 0 2.1693408648632898e+19
Gr11_im_1_1 0 s1 x11_im_a1 0 -4.719394959641585e+19
Gr12_re_1_1 0 s1 x12_re_a1 0 -2.0763966462208708e+20
Gr12_im_1_1 0 s1 x12_im_a1 0 -6.505359467100241e+18
Gr13_re_1_1 0 s1 x13_re_a1 0 5.2505577212666085e+19
Gr13_im_1_1 0 s1 x13_im_a1 0 4.016819299142203e+19
Gr14_re_1_1 0 s1 x14_re_a1 0 3.0725587431217553e+19
Gr14_im_1_1 0 s1 x14_im_a1 0 -7.083700763557096e+18
Gr15_re_1_1 0 s1 x15_re_a1 0 4.163111993874752e+19
Gr15_im_1_1 0 s1 x15_im_a1 0 2.7427019819393053e+19
Gr16_re_1_1 0 s1 x16_re_a1 0 1.1738706770248442e+20
Gr16_im_1_1 0 s1 x16_im_a1 0 6.0771619812345045e+19
Gr17_re_1_1 0 s1 x17_re_a1 0 -4.552349867089048e+19
Gr17_im_1_1 0 s1 x17_im_a1 0 -8.807365085731501e+19
Gr18_re_1_1 0 s1 x18_re_a1 0 2.9310939978511237e+19
Gr18_im_1_1 0 s1 x18_im_a1 0 -1.0596798762214337e+18
Gr19_re_1_1 0 s1 x19_re_a1 0 -1.3033445418105202e+20
Gr19_im_1_1 0 s1 x19_im_a1 0 -7.526750769554529e+19
Gr20_re_1_1 0 s1 x20_re_a1 0 3.5192905301714396e+18
Gr20_im_1_1 0 s1 x20_im_a1 0 -4.160427505418723e+17
Gr21_re_1_1 0 s1 x21_re_a1 0 -1.2103563302360526e+20
Gr21_im_1_1 0 s1 x21_im_a1 0 1.5260354414314375e+19
Gr22_re_1_1 0 s1 x22_re_a1 0 3.865381970703388e+19
Gr22_im_1_1 0 s1 x22_im_a1 0 2.3684182463715148e+19
Gr23_re_1_1 0 s1 x23_re_a1 0 -4.605073315911756e+19
Gr23_im_1_1 0 s1 x23_im_a1 0 4.446994241619419e+19
Gr24_re_1_1 0 s1 x24_re_a1 0 8.197454796543626e+19
Gr24_im_1_1 0 s1 x24_im_a1 0 2.2353096428757235e+18
Gr25_re_1_1 0 s1 x25_re_a1 0 1.688808271011939e+18
Gr25_im_1_1 0 s1 x25_im_a1 0 3.018021067269357e+19
Gr26_re_1_1 0 s1 x26_re_a1 0 1.2857291864857272e+20
Gr26_im_1_1 0 s1 x26_im_a1 0 4.908819339532536e+19
Gr27_re_1_1 0 s1 x27_re_a1 0 8.892526263568655e+18
Gr27_im_1_1 0 s1 x27_im_a1 0 6.799231791782469e+18
Gr28_re_1_1 0 s1 x28_re_a1 0 2.1291228358839726e+19
Gr28_im_1_1 0 s1 x28_im_a1 0 -2.9371764666020905e+19
Gr29_re_1_1 0 s1 x29_re_a1 0 6.381368089869123e+19
Gr29_im_1_1 0 s1 x29_im_a1 0 5.283634850125011e+19
Gr30_re_1_1 0 s1 x30_re_a1 0 3.0010365097453253e+19
Gr30_im_1_1 0 s1 x30_im_a1 0 -1.4571841864899174e+20
Gr31_re_1_1 0 s1 x31_re_a1 0 -6.659812534429568e+19
Gr31_im_1_1 0 s1 x31_im_a1 0 -2.172555772546846e+19
Gr32_re_1_1 0 s1 x32_re_a1 0 -2.8217350957925016e+19
Gr32_im_1_1 0 s1 x32_im_a1 0 1.876557361147318e+19
Gr33_re_1_1 0 s1 x33_re_a1 0 -5.101890283960676e+19
Gr33_im_1_1 0 s1 x33_im_a1 0 -4.042064337876749e+19
Gr34_re_1_1 0 s1 x34_re_a1 0 -7.982410236010483e+19
Gr34_im_1_1 0 s1 x34_im_a1 0 -1.917358413960898e+19
Gr35_re_1_1 0 s1 x35_re_a1 0 -3.217200367965195e+19
Gr35_im_1_1 0 s1 x35_im_a1 0 -4.160815679371269e+19
Gr36_re_1_1 0 s1 x36_re_a1 0 -4.15075606642589e+17
Gr36_im_1_1 0 s1 x36_im_a1 0 1.7029071192363141e+19
Gr37_re_1_1 0 s1 x37_re_a1 0 1.8668798228727415e+20
Gr37_im_1_1 0 s1 x37_im_a1 0 1.4860414276522348e+20
Gr38_re_1_1 0 s1 x38_re_a1 0 -6.553427459748819e+19
Gr38_im_1_1 0 s1 x38_im_a1 0 -3.5675546527130132e+19
Gr39_re_1_1 0 s1 x39_re_a1 0 -9.074702763890357e+18
Gr39_im_1_1 0 s1 x39_im_a1 0 -3.5800220282859356e+19
Gr40_re_1_1 0 s1 x40_re_a1 0 -9.338878518418651e+18
Gr40_im_1_1 0 s1 x40_im_a1 0 6.665612801924556e+19
Gr41_re_1_1 0 s1 x41_re_a1 0 2.6433265164177076e+19
Gr41_im_1_1 0 s1 x41_im_a1 0 -4.829608566858474e+19
Gr42_re_1_1 0 s1 x42_re_a1 0 -1.7814185829221294e+19
Gr42_im_1_1 0 s1 x42_im_a1 0 2.251863053511845e+19
Gr43_re_1_1 0 s1 x43_re_a1 0 5.392814220598554e+19
Gr43_im_1_1 0 s1 x43_im_a1 0 6.585805684926186e+18
Gr44_re_1_1 0 s1 x44_re_a1 0 2.675325794912387e+19
Gr44_im_1_1 0 s1 x44_im_a1 0 -3.1207174522737283e+19
Gr45_re_1_1 0 s1 x45_re_a1 0 5.3160968562897715e+19
Gr45_im_1_1 0 s1 x45_im_a1 0 1.3836302969134856e+17
Gr46_re_1_1 0 s1 x46_re_a1 0 -5.393682803028358e+19
Gr46_im_1_1 0 s1 x46_im_a1 0 -3.4240921950282252e+19
Gr47_re_1_1 0 s1 x47_re_a1 0 4.425573551493252e+19
Gr47_im_1_1 0 s1 x47_im_a1 0 -2.21042104344246e+19
Gr48_re_1_1 0 s1 x48_re_a1 0 2.6478395456402326e+19
Gr48_im_1_1 0 s1 x48_im_a1 0 -1.367181500915469e+18
Gr49_re_1_1 0 s1 x49_re_a1 0 1.5816130351512297e+19
Gr49_im_1_1 0 s1 x49_im_a1 0 6.970781747070591e+18
Gr50_re_1_1 0 s1 x50_re_a1 0 -7.137785156586359e+18
Gr50_im_1_1 0 s1 x50_im_a1 0 4.852831098462427e+18
Gr51_re_1_1 0 s1 x51_re_a1 0 -2.169538871862258e+19
Gr51_im_1_1 0 s1 x51_im_a1 0 2.3898718110300073e+18
Gr52_re_1_1 0 s1 x52_re_a1 0 -2.4235138840948765e+19
Gr52_im_1_1 0 s1 x52_im_a1 0 1.880373552723029e+18
Gr53_re_1_1 0 s1 x53_re_a1 0 -2.93692964528616e+19
Gr53_im_1_1 0 s1 x53_im_a1 0 9.729939153321989e+17
Gr54_re_1_1 0 s1 x54_re_a1 0 -3.1370038569286705e+19
Gr54_im_1_1 0 s1 x54_im_a1 0 6.782015650497631e+17
Gr55_re_1_1 0 s1 x55_re_a1 0 -3.234507542432725e+19
Gr55_im_1_1 0 s1 x55_im_a1 0 4.195366364349176e+17
Gr56_re_1_1 0 s1 x56_re_a1 0 -3.024137060447389e+19
Gr56_im_1_1 0 s1 x56_im_a1 0 2.3175800059192736e+17
Gr57_re_1_1 0 s1 x57_re_a1 0 -9.87828141901661e+18
Gr57_im_1_1 0 s1 x57_im_a1 0 3.98560106481068e+16
Gr58_re_1_1 0 s1 x58_re_a1 0 -2.251643976249537e+19
Gr58_im_1_1 0 s1 x58_im_a1 0 1.0894599737529466e+17
Gr59_re_1_1 0 s1 x59_re_a1 0 -5.257542049041274e+16
Gr59_im_1_1 0 s1 x59_im_a1 0 835743754405194.0
Gr60_re_1_1 0 s1 x60_re_a1 0 -1.664942996473654e+18
Gr60_im_1_1 0 s1 x60_im_a1 0 9210870202645880.0
Gd1_2 0 s1 p2 0 0.0007401079557176113
Fd1_2 0 s1 V2 0.037005397785880564
Gr1_re_1_2 0 s1 x1_re_a2 0 53134911250.26852
Gr1_im_1_2 0 s1 x1_im_a2 0 -85709370845.99294
Gr2_re_1_2 0 s1 x2_re_a2 0 1.0334313050772204e+16
Gr2_im_1_2 0 s1 x2_im_a2 0 -9190339535486750.0
Gr3_re_1_2 0 s1 x3_re_a2 0 -1.3490123146488925e+17
Gr3_im_1_2 0 s1 x3_im_a2 0 -9.569989710018098e+16
Gr4_re_1_2 0 s1 x4_re_a2 0 2.121695772289807e+17
Gr4_im_1_2 0 s1 x4_im_a2 0 4.200343777771361e+17
Gr5_re_1_2 0 s1 x5_re_a2 0 2.0770366756760904e+18
Gr5_im_1_2 0 s1 x5_im_a2 0 -4.7011429477342086e+17
Gr6_re_1_2 0 s1 x6_re_a2 0 2.8061699763707674e+17
Gr6_im_1_2 0 s1 x6_im_a2 0 2.1227528416691853e+18
Gr7_re_1_2 0 s1 x7_re_a2 0 1.7107679968313943e+18
Gr7_im_1_2 0 s1 x7_im_a2 0 -5.439337411865897e+18
Gr8_re_1_2 0 s1 x8_re_a2 0 4.450964821611498e+18
Gr8_im_1_2 0 s1 x8_im_a2 0 -4.513312567971629e+18
Gr9_re_1_2 0 s1 x9_re_a2 0 -1.24577159388261e+19
Gr9_im_1_2 0 s1 x9_im_a2 0 -1.6785753197510243e+17
Gr10_re_1_2 0 s1 x10_re_a2 0 -1.5333252664220595e+20
Gr10_im_1_2 0 s1 x10_im_a2 0 -4.3766927672833114e+19
Gr11_re_1_2 0 s1 x11_re_a2 0 -4.436303712958498e+19
Gr11_im_1_2 0 s1 x11_im_a2 0 1.0644948471461723e+20
Gr12_re_1_2 0 s1 x12_re_a2 0 4.623521115659791e+20
Gr12_im_1_2 0 s1 x12_im_a2 0 -2.092920720103389e+17
Gr13_re_1_2 0 s1 x13_re_a2 0 -1.190089978199833e+20
Gr13_im_1_2 0 s1 x13_im_a2 0 -8.702411259588883e+19
Gr14_re_1_2 0 s1 x14_re_a2 0 -6.9530625972406166e+19
Gr14_im_1_2 0 s1 x14_im_a2 0 1.1393646110262856e+19
Gr15_re_1_2 0 s1 x15_re_a2 0 -9.482634540208929e+19
Gr15_im_1_2 0 s1 x15_im_a2 0 -5.333591074097742e+19
Gr16_re_1_2 0 s1 x16_re_a2 0 -2.648529389527868e+20
Gr16_im_1_2 0 s1 x16_im_a2 0 -1.276070532210893e+20
Gr17_re_1_2 0 s1 x17_re_a2 0 1.0447172488477139e+20
Gr17_im_1_2 0 s1 x17_im_a2 0 1.9622895871173185e+20
Gr18_re_1_2 0 s1 x18_re_a2 0 -6.353012769125583e+19
Gr18_im_1_2 0 s1 x18_im_a2 0 6.567843289323451e+18
Gr19_re_1_2 0 s1 x19_re_a2 0 2.9495838168812772e+20
Gr19_im_1_2 0 s1 x19_im_a2 0 1.620010716546841e+20
Gr20_re_1_2 0 s1 x20_re_a2 0 -5.124222685887446e+18
Gr20_im_1_2 0 s1 x20_im_a2 0 -1.5207122670426208e+17
Gr21_re_1_2 0 s1 x21_re_a2 0 2.691627243339899e+20
Gr21_im_1_2 0 s1 x21_im_a2 0 -4.0535873216894575e+19
Gr22_re_1_2 0 s1 x22_re_a2 0 -8.512739616984333e+19
Gr22_im_1_2 0 s1 x22_im_a2 0 -5.538056995976048e+19
Gr23_re_1_2 0 s1 x23_re_a2 0 9.932431467147516e+19
Gr23_im_1_2 0 s1 x23_im_a2 0 -1.027859540915992e+20
Gr24_re_1_2 0 s1 x24_re_a2 0 -1.8299970673572908e+20
Gr24_im_1_2 0 s1 x24_im_a2 0 -6.854742553111188e+18
Gr25_re_1_2 0 s1 x25_re_a2 0 -8.131005693568003e+18
Gr25_im_1_2 0 s1 x25_im_a2 0 -6.627633859802802e+19
Gr26_re_1_2 0 s1 x26_re_a2 0 -2.8868828677946648e+20
Gr26_im_1_2 0 s1 x26_im_a2 0 -1.0506930721689112e+20
Gr27_re_1_2 0 s1 x27_re_a2 0 -2.2259184283600384e+19
Gr27_im_1_2 0 s1 x27_im_a2 0 -1.2971717416804913e+19
Gr28_re_1_2 0 s1 x28_re_a2 0 -4.724656972322288e+19
Gr28_im_1_2 0 s1 x28_im_a2 0 6.5742449111085285e+19
Gr29_re_1_2 0 s1 x29_re_a2 0 -1.4514956326886556e+20
Gr29_im_1_2 0 s1 x29_im_a2 0 -1.1231238995281617e+20
Gr30_re_1_2 0 s1 x30_re_a2 0 -5.99644098991686e+19
Gr30_im_1_2 0 s1 x30_im_a2 0 3.3242533981531406e+20
Gr31_re_1_2 0 s1 x31_re_a2 0 1.477545589438418e+20
Gr31_im_1_2 0 s1 x31_im_a2 0 4.6047798160492536e+19
Gr32_re_1_2 0 s1 x32_re_a2 0 6.260125598653283e+19
Gr32_im_1_2 0 s1 x32_im_a2 0 -3.6885317019684356e+19
Gr33_re_1_2 0 s1 x33_re_a2 0 1.1642206761525648e+20
Gr33_im_1_2 0 s1 x33_im_a2 0 8.587967536822283e+19
Gr34_re_1_2 0 s1 x34_re_a2 0 1.7773761237135593e+20
Gr34_im_1_2 0 s1 x34_im_a2 0 4.530519990872223e+19
Gr35_re_1_2 0 s1 x35_re_a2 0 7.48844631582957e+19
Gr35_im_1_2 0 s1 x35_im_a2 0 8.986208989916201e+19
Gr36_re_1_2 0 s1 x36_re_a2 0 2.8254206090727316e+18
Gr36_im_1_2 0 s1 x36_im_a2 0 -3.8012250752580256e+19
Gr37_re_1_2 0 s1 x37_re_a2 0 -4.2745691787155e+20
Gr37_im_1_2 0 s1 x37_im_a2 0 -3.424710349279993e+20
Gr38_re_1_2 0 s1 x38_re_a2 0 1.4698117455575609e+20
Gr38_im_1_2 0 s1 x38_im_a2 0 7.783921760528322e+19
Gr39_re_1_2 0 s1 x39_re_a2 0 2.4181636112998085e+19
Gr39_im_1_2 0 s1 x39_im_a2 0 7.674509986975577e+19
Gr40_re_1_2 0 s1 x40_re_a2 0 1.952165129416457e+19
Gr40_im_1_2 0 s1 x40_im_a2 0 -1.4880305139968908e+20
Gr41_re_1_2 0 s1 x41_re_a2 0 -6.4950521355327226e+19
Gr41_im_1_2 0 s1 x41_im_a2 0 1.0183706575842373e+20
Gr42_re_1_2 0 s1 x42_re_a2 0 4.26689472238081e+19
Gr42_im_1_2 0 s1 x42_im_a2 0 -4.256038696010595e+19
Gr43_re_1_2 0 s1 x43_re_a2 0 -1.2047918089401211e+20
Gr43_im_1_2 0 s1 x43_im_a2 0 -9.999324040620196e+18
Gr44_re_1_2 0 s1 x44_re_a2 0 -6.002194036231466e+19
Gr44_im_1_2 0 s1 x44_im_a2 0 6.979342697920696e+19
Gr45_re_1_2 0 s1 x45_re_a2 0 -1.1716112906632703e+20
Gr45_im_1_2 0 s1 x45_im_a2 0 5.850314143395089e+18
Gr46_re_1_2 0 s1 x46_re_a2 0 1.206441068570355e+20
Gr46_im_1_2 0 s1 x46_im_a2 0 7.893574461873067e+19
Gr47_re_1_2 0 s1 x47_re_a2 0 -9.739089820068045e+19
Gr47_im_1_2 0 s1 x47_im_a2 0 5.233335025359747e+19
Gr48_re_1_2 0 s1 x48_re_a2 0 -5.749227519307608e+19
Gr48_im_1_2 0 s1 x48_im_a2 0 6.327755498773132e+18
Gr49_re_1_2 0 s1 x49_re_a2 0 -3.424964850848471e+19
Gr49_im_1_2 0 s1 x49_im_a2 0 -1.3120747451020308e+19
Gr50_re_1_2 0 s1 x50_re_a2 0 1.6403527176998824e+19
Gr50_im_1_2 0 s1 x50_im_a2 0 -9.681105475183905e+18
Gr51_re_1_2 0 s1 x51_re_a2 0 4.86129762789145e+19
Gr51_im_1_2 0 s1 x51_im_a2 0 -4.80035814631497e+18
Gr52_re_1_2 0 s1 x52_re_a2 0 5.427919085237055e+19
Gr52_im_1_2 0 s1 x52_im_a2 0 -3.7683643763382676e+18
Gr53_re_1_2 0 s1 x53_re_a2 0 6.566830049566466e+19
Gr53_im_1_2 0 s1 x53_im_a2 0 -1.947162884346651e+18
Gr54_re_1_2 0 s1 x54_re_a2 0 7.0066284275941196e+19
Gr54_im_1_2 0 s1 x54_im_a2 0 -1.3599041955848858e+18
Gr55_re_1_2 0 s1 x55_re_a2 0 7.217951832077812e+19
Gr55_im_1_2 0 s1 x55_im_a2 0 -8.427886555922115e+17
Gr56_re_1_2 0 s1 x56_re_a2 0 6.7444384819450855e+19
Gr56_im_1_2 0 s1 x56_im_a2 0 -4.6607281421249594e+17
Gr57_re_1_2 0 s1 x57_re_a2 0 2.201702907246334e+19
Gr57_im_1_2 0 s1 x57_im_a2 0 -8.022542152322235e+16
Gr58_re_1_2 0 s1 x58_re_a2 0 5.019725766655148e+19
Gr58_im_1_2 0 s1 x58_im_a2 0 -2.1924669162351258e+17
Gr59_re_1_2 0 s1 x59_re_a2 0 1.1715568826915243e+17
Gr59_im_1_2 0 s1 x59_im_a2 0 -1683584090355236.0
Gr60_re_1_2 0 s1 x60_re_a2 0 3.710406904300773e+18
Gr60_im_1_2 0 s1 x60_im_a2 0 -1.854255346675521e+16
Gd1_3 0 s1 p3 0 0.00020524649245470846
Fd1_3 0 s1 V3 0.010262324622735424
Gr1_re_1_3 0 s1 x1_re_a3 0 18555558497.57305
Gr1_im_1_3 0 s1 x1_im_a3 0 -26242428014.738094
Gr2_re_1_3 0 s1 x2_re_a3 0 3429285605292932.0
Gr2_im_1_3 0 s1 x2_im_a3 0 -2790552853106522.0
Gr3_re_1_3 0 s1 x3_re_a3 0 -4.178381757580026e+16
Gr3_im_1_3 0 s1 x3_im_a3 0 -3.239985737984487e+16
Gr4_re_1_3 0 s1 x4_re_a3 0 6.223625017272953e+16
Gr4_im_1_3 0 s1 x4_im_a3 0 1.3695747021513466e+17
Gr5_re_1_3 0 s1 x5_re_a3 0 6.64552235509796e+17
Gr5_im_1_3 0 s1 x5_im_a3 0 -1.25407429210406e+17
Gr6_re_1_3 0 s1 x6_re_a3 0 6.414986070682369e+16
Gr6_im_1_3 0 s1 x6_im_a3 0 6.816251360342388e+17
Gr7_re_1_3 0 s1 x7_re_a3 0 6.097969995377016e+17
Gr7_im_1_3 0 s1 x7_im_a3 0 -1.7180474500099456e+18
Gr8_re_1_3 0 s1 x8_re_a3 0 1.4695813797889124e+18
Gr8_im_1_3 0 s1 x8_im_a3 0 -1.3960940655426145e+18
Gr9_re_1_3 0 s1 x9_re_a3 0 -3.979851567340643e+18
Gr9_im_1_3 0 s1 x9_im_a3 0 -1.7195350052947053e+17
Gr10_re_1_3 0 s1 x10_re_a3 0 -4.867044918543964e+19
Gr10_im_1_3 0 s1 x10_im_a3 0 -1.5182660337884486e+19
Gr11_re_1_3 0 s1 x11_re_a3 0 -1.4948730862123356e+19
Gr11_im_1_3 0 s1 x11_im_a3 0 3.370962962293254e+19
Gr12_re_1_3 0 s1 x12_re_a3 0 1.477289698925652e+20
Gr12_im_1_3 0 s1 x12_im_a3 0 2.8204746071833405e+18
Gr13_re_1_3 0 s1 x13_re_a3 0 -3.768494066184966e+19
Gr13_im_1_3 0 s1 x13_im_a3 0 -2.8325900735108293e+19
Gr14_re_1_3 0 s1 x14_re_a3 0 -2.2326242099380703e+19
Gr14_im_1_3 0 s1 x14_im_a3 0 4.539753193399346e+18
Gr15_re_1_3 0 s1 x15_re_a3 0 -2.9679198137045385e+19
Gr15_im_1_3 0 s1 x15_im_a3 0 -1.8525364416460755e+19
Gr16_re_1_3 0 s1 x16_re_a3 0 -8.403869471863706e+19
Gr16_im_1_3 0 s1 x16_im_a3 0 -4.2343014277220295e+19
Gr17_re_1_3 0 s1 x17_re_a3 0 3.293752825690886e+19
Gr17_im_1_3 0 s1 x17_im_a3 0 6.2878964361611305e+19
Gr18_re_1_3 0 s1 x18_re_a3 0 -2.0563249791683867e+19
Gr18_im_1_3 0 s1 x18_im_a3 0 1.2229194078904591e+18
Gr19_re_1_3 0 s1 x19_re_a3 0 9.35781731224039e+19
Gr19_im_1_3 0 s1 x19_im_a3 0 5.29490701638292e+19
Gr20_re_1_3 0 s1 x20_re_a3 0 -2.2051714244094118e+18
Gr20_im_1_3 0 s1 x20_im_a3 0 5.3294537749822616e+16
Gr21_re_1_3 0 s1 x21_re_a3 0 8.627513177694993e+19
Gr21_im_1_3 0 s1 x21_im_a3 0 -1.1719334311018047e+19
Gr22_re_1_3 0 s1 x22_re_a3 0 -2.7611501630333534e+19
Gr22_im_1_3 0 s1 x22_im_a3 0 -1.7325867280638908e+19
Gr23_re_1_3 0 s1 x23_re_a3 0 3.239746038187188e+19
Gr23_im_1_3 0 s1 x23_im_a3 0 -3.2167630347843002e+19
Gr24_re_1_3 0 s1 x24_re_a3 0 -5.8748455700165075e+19
Gr24_im_1_3 0 s1 x24_im_a3 0 -1.849988042981256e+18
Gr25_re_1_3 0 s1 x25_re_a3 0 -1.7389649125901624e+18
Gr25_im_1_3 0 s1 x25_im_a3 0 -2.132413816270694e+19
Gr26_re_1_3 0 s1 x26_re_a3 0 -9.212548753737107e+19
Gr26_im_1_3 0 s1 x26_im_a3 0 -3.451416563745202e+19
Gr27_re_1_3 0 s1 x27_re_a3 0 -6.612865630627338e+18
Gr27_im_1_3 0 s1 x27_im_a3 0 -4.512091533208174e+18
Gr28_re_1_3 0 s1 x28_re_a3 0 -1.5203415732187273e+19
Gr28_im_1_3 0 s1 x28_im_a3 0 2.104108277398522e+19
Gr29_re_1_3 0 s1 x29_re_a3 0 -4.587756351265013e+19
Gr29_im_1_3 0 s1 x29_im_a3 0 -3.702367086168021e+19
Gr30_re_1_3 0 s1 x30_re_a3 0 -2.0392989303385944e+19
Gr30_im_1_3 0 s1 x30_im_a3 0 1.0506605644744283e+20
Gr31_re_1_3 0 s1 x31_re_a3 0 4.7498616123045814e+19
Gr31_im_1_3 0 s1 x31_im_a3 0 1.5264170546466103e+19
Gr32_re_1_3 0 s1 x32_re_a3 0 2.027266258497243e+19
Gr32_im_1_3 0 s1 x32_im_a3 0 -1.2773430279075863e+19
Gr33_re_1_3 0 s1 x33_re_a3 0 3.6751286135976358e+19
Gr33_im_1_3 0 s1 x33_im_a3 0 2.8318848688083948e+19
Gr34_re_1_3 0 s1 x34_re_a3 0 5.71407393105884e+19
Gr34_im_1_3 0 s1 x34_im_a3 0 1.4065548323287882e+19
Gr35_re_1_3 0 s1 x35_re_a3 0 2.3366568562153705e+19
Gr35_im_1_3 0 s1 x35_im_a3 0 2.9337495763510424e+19
Gr36_re_1_3 0 s1 x36_re_a3 0 5.447756116879889e+17
Gr36_im_1_3 0 s1 x36_im_a3 0 -1.2227554944860342e+19
Gr37_re_1_3 0 s1 x37_re_a3 0 -1.3523033039199948e+20
Gr37_im_1_3 0 s1 x37_im_a3 0 -1.076686265744923e+20
Gr38_re_1_3 0 s1 x38_re_a3 0 4.697298125883628e+19
Gr38_im_1_3 0 s1 x38_im_a3 0 2.529790690445412e+19
Gr39_re_1_3 0 s1 x39_re_a3 0 6.944434212427563e+18
Gr39_im_1_3 0 s1 x39_im_a3 0 2.515241270715411e+19
Gr40_re_1_3 0 s1 x40_re_a3 0 6.518929780280822e+18
Gr40_im_1_3 0 s1 x40_im_a3 0 -4.769839651313926e+19
Gr41_re_1_3 0 s1 x41_re_a3 0 -1.9761178269057372e+19
Gr41_im_1_3 0 s1 x41_im_a3 0 3.386630765848711e+19
Gr42_re_1_3 0 s1 x42_re_a3 0 1.3207480314676759e+19
Gr42_im_1_3 0 s1 x42_im_a3 0 -1.5151620391702155e+19
Gr43_re_1_3 0 s1 x43_re_a3 0 -3.8589911704060305e+19
Gr43_im_1_3 0 s1 x43_im_a3 0 -4.1070358872500147e+18
Gr44_re_1_3 0 s1 x44_re_a3 0 -1.9192584975978332e+19
Gr44_im_1_3 0 s1 x44_im_a3 0 2.23602118543163e+19
Gr45_re_1_3 0 s1 x45_re_a3 0 -3.783729998566113e+19
Gr45_im_1_3 0 s1 x45_im_a3 0 6.910857903844532e+17
Gr46_re_1_3 0 s1 x46_re_a3 0 3.865640932571437e+19
Gr46_im_1_3 0 s1 x46_im_a3 0 2.483916055188301e+19
Gr47_re_1_3 0 s1 x47_re_a3 0 -3.1499380446445146e+19
Gr47_im_1_3 0 s1 x47_im_a3 0 1.6208090197917567e+19
Gr48_re_1_3 0 s1 x48_re_a3 0 -1.8742381605820555e+19
Gr48_im_1_3 0 s1 x48_im_a3 0 1.4009340160575542e+18
Gr49_re_1_3 0 s1 x49_re_a3 0 -1.118114749773876e+19
Gr49_im_1_3 0 s1 x49_im_a3 0 -4.675292600275552e+18
Gr50_re_1_3 0 s1 x50_re_a3 0 5.17451063745053e+18
Gr50_im_1_3 0 s1 x50_im_a3 0 -3.325113526563385e+18
Gr51_re_1_3 0 s1 x51_re_a3 0 1.5558032420879878e+19
Gr51_im_1_3 0 s1 x51_im_a3 0 -1.641713899400599e+18
Gr52_re_1_3 0 s1 x52_re_a3 0 1.737563202630415e+19
Gr52_im_1_3 0 s1 x52_im_a3 0 -1.29059736446762e+18
Gr53_re_1_3 0 s1 x53_re_a3 0 2.104114606094377e+19
Gr53_im_1_3 0 s1 x53_im_a3 0 -6.674581160966808e+17
Gr54_re_1_3 0 s1 x54_re_a3 0 2.246437611152841e+19
Gr54_im_1_3 0 s1 x54_im_a3 0 -4.655799008197863e+17
Gr55_re_1_3 0 s1 x55_re_a3 0 2.3153901042818118e+19
Gr55_im_1_3 0 s1 x55_im_a3 0 -2.882072817700334e+17
Gr56_re_1_3 0 s1 x56_re_a3 0 2.1642463930601865e+19
Gr56_im_1_3 0 s1 x56_im_a3 0 -1.5927443907963952e+17
Gr57_re_1_3 0 s1 x57_re_a3 0 7.067610971421812e+18
Gr57_im_1_3 0 s1 x57_im_a3 0 -2.740032394937899e+16
Gr58_re_1_3 0 s1 x58_re_a3 0 1.6111442809397811e+19
Gr58_im_1_3 0 s1 x58_im_a3 0 -7.4892076942125e+16
Gr59_re_1_3 0 s1 x59_re_a3 0 3.761251256078209e+16
Gr59_im_1_3 0 s1 x59_im_a3 0 -574723942140410.5
Gr60_re_1_3 0 s1 x60_re_a3 0 1.191150024931656e+18
Gr60_im_1_3 0 s1 x60_im_a3 0 -6332590858325922.0
Gd1_4 0 s1 p4 0 1.255530711740544e-06
Fd1_4 0 s1 V4 6.27765355870272e-05
Gr1_re_1_4 0 s1 x1_re_a4 0 -8857527431.953907
Gr1_im_1_4 0 s1 x1_im_a4 0 13863615094.477682
Gr2_re_1_4 0 s1 x2_re_a4 0 -1703130895210979.2
Gr2_im_1_4 0 s1 x2_im_a4 0 1492898482227779.5
Gr3_re_1_4 0 s1 x3_re_a4 0 2.198687658680522e+16
Gr3_im_1_4 0 s1 x3_im_a4 0 1.5826632195239892e+16
Gr4_re_1_4 0 s1 x4_re_a4 0 -3.4300987276714892e+16
Gr4_im_1_4 0 s1 x4_im_a4 0 -6.903835251765888e+16
Gr5_re_1_4 0 s1 x5_re_a4 0 -3.404262101985441e+17
Gr5_im_1_4 0 s1 x5_im_a4 0 7.535930346227082e+16
Gr6_re_1_4 0 s1 x6_re_a4 0 -4.392860640611418e+16
Gr6_im_1_4 0 s1 x6_im_a4 0 -3.4818805397256064e+17
Gr7_re_1_4 0 s1 x7_re_a4 0 -2.855011502603737e+17
Gr7_im_1_4 0 s1 x7_im_a4 0 8.900326929452242e+17
Gr8_re_1_4 0 s1 x8_re_a4 0 -7.336756149361651e+17
Gr8_im_1_4 0 s1 x8_im_a4 0 7.365354896218888e+17
Gr9_re_1_4 0 s1 x9_re_a4 0 2.0436085399974047e+18
Gr9_im_1_4 0 s1 x9_im_a4 0 3.669967915476388e+16
Gr10_re_1_4 0 s1 x10_re_a4 0 2.514335290476222e+19
Gr10_im_1_4 0 s1 x10_im_a4 0 7.274128569412766e+18
Gr11_re_1_4 0 s1 x11_re_a4 0 7.340842979219367e+18
Gr11_im_1_4 0 s1 x11_im_a4 0 -1.7452650526439723e+19
Gr12_re_1_4 0 s1 x12_re_a4 0 -7.592168964981444e+19
Gr12_im_1_4 0 s1 x12_im_a4 0 -1.7520179485994198e+17
Gr13_re_1_4 0 s1 x13_re_a4 0 1.9528011276850786e+19
Gr13_im_1_4 0 s1 x13_im_a4 0 1.433447355525812e+19
Gr14_re_1_4 0 s1 x14_re_a4 0 1.1474210598287864e+19
Gr14_im_1_4 0 s1 x14_im_a4 0 -1.9418763685973466e+18
Gr15_re_1_4 0 s1 x15_re_a4 0 1.5496360582279125e+19
Gr15_im_1_4 0 s1 x15_im_a4 0 8.860428208034797e+18
Gr16_re_1_4 0 s1 x16_re_a4 0 4.3462368184307876e+19
Gr16_im_1_4 0 s1 x16_im_a4 0 2.107620597151666e+19
Gr17_re_1_4 0 s1 x17_re_a4 0 -1.7147618374577603e+19
Gr17_im_1_4 0 s1 x17_im_a4 0 -3.22655431680574e+19
Gr18_re_1_4 0 s1 x18_re_a4 0 1.0439904730649192e+19
Gr18_im_1_4 0 s1 x18_im_a4 0 -1.0077079118585626e+18
Gr19_re_1_4 0 s1 x19_re_a4 0 -4.842544993783231e+19
Gr19_im_1_4 0 s1 x19_im_a4 0 -2.6700969492330177e+19
Gr20_re_1_4 0 s1 x20_re_a4 0 8.878345377902406e+17
Gr20_im_1_4 0 s1 x20_im_a4 0 3.3893789002626424e+16
Gr21_re_1_4 0 s1 x21_re_a4 0 -4.424877182966162e+19
Gr21_im_1_4 0 s1 x21_im_a4 0 6.575000724920752e+18
Gr22_re_1_4 0 s1 x22_re_a4 0 1.4042034294072582e+19
Gr22_im_1_4 0 s1 x22_im_a4 0 9.089410824413033e+18
Gr23_re_1_4 0 s1 x23_re_a4 0 -1.6362249389742754e+19
Gr23_im_1_4 0 s1 x23_im_a4 0 1.68389833404463e+19
Gr24_re_1_4 0 s1 x24_re_a4 0 3.0124717461344555e+19
Gr24_im_1_4 0 s1 x24_im_a4 0 1.1052110728890894e+18
Gr25_re_1_4 0 s1 x25_re_a4 0 1.2727580532328543e+18
Gr25_im_1_4 0 s1 x25_im_a4 0 1.0888731518457098e+19
Gr26_re_1_4 0 s1 x26_re_a4 0 4.744909500135924e+19
Gr26_im_1_4 0 s1 x26_im_a4 0 1.7338088499262697e+19
Gr27_re_1_4 0 s1 x27_re_a4 0 3.6164551273710894e+18
Gr27_im_1_4 0 s1 x27_im_a4 0 2.1480430806370048e+18
Gr28_re_1_4 0 s1 x28_re_a4 0 7.777234675786256e+18
Gr28_im_1_4 0 s1 x28_im_a4 0 -1.0813101811357235e+19
Gr29_re_1_4 0 s1 x29_re_a4 0 2.381318040574931e+19
Gr29_im_1_4 0 s1 x29_im_a4 0 1.8538409406018544e+19
Gr30_re_1_4 0 s1 x30_re_a4 0 9.919263846686693e+18
Gr30_im_1_4 0 s1 x30_im_a4 0 -5.456460201707078e+19
Gr31_re_1_4 0 s1 x31_re_a4 0 -2.4310426296119575e+19
Gr31_im_1_4 0 s1 x31_im_a4 0 -7.615329317543764e+18
Gr32_re_1_4 0 s1 x32_re_a4 0 -1.0332653734531197e+19
Gr32_im_1_4 0 s1 x32_im_a4 0 6.132303466244741e+18
Gr33_re_1_4 0 s1 x33_re_a4 0 -1.9100623819860374e+19
Gr33_im_1_4 0 s1 x33_im_a4 0 -1.4176070661394866e+19
Gr34_re_1_4 0 s1 x34_re_a4 0 -2.926310514647838e+19
Gr34_im_1_4 0 s1 x34_im_a4 0 -7.424959069852171e+18
Gr35_re_1_4 0 s1 x35_re_a4 0 -1.2267418102941153e+19
Gr35_im_1_4 0 s1 x35_im_a4 0 -1.4812931378668435e+19
Gr36_re_1_4 0 s1 x36_re_a4 0 -4.402719226446789e+17
Gr36_im_1_4 0 s1 x36_im_a4 0 6.262741700838086e+18
Gr37_re_1_4 0 s1 x37_re_a4 0 7.023611322803615e+19
Gr37_im_1_4 0 s1 x37_im_a4 0 5.618556008725358e+19
Gr38_re_1_4 0 s1 x38_re_a4 0 -2.416839380571736e+19
Gr38_im_1_4 0 s1 x38_im_a4 0 -1.282953417001276e+19
Gr39_re_1_4 0 s1 x39_re_a4 0 -3.913858251131819e+18
Gr39_im_1_4 0 s1 x39_im_a4 0 -1.2654968961279453e+19
Gr40_re_1_4 0 s1 x40_re_a4 0 -3.230701926891604e+18
Gr40_im_1_4 0 s1 x40_im_a4 0 2.4479525572794188e+19
Gr41_re_1_4 0 s1 x41_re_a4 0 1.0623800073889518e+19
Gr41_im_1_4 0 s1 x41_im_a4 0 -1.6849534590527257e+19
Gr42_re_1_4 0 s1 x42_re_a4 0 -6.999936645356892e+18
Gr42_im_1_4 0 s1 x42_im_a4 0 7.110892281540256e+18
Gr43_re_1_4 0 s1 x43_re_a4 0 1.981611196022988e+19
Gr43_im_1_4 0 s1 x43_im_a4 0 1.7075476818976072e+18
Gr44_re_1_4 0 s1 x44_re_a4 0 9.872403810636067e+18
Gr44_im_1_4 0 s1 x44_im_a4 0 -1.1482739902639235e+19
Gr45_re_1_4 0 s1 x45_re_a4 0 1.9292310711550136e+19
Gr45_im_1_4 0 s1 x45_im_a4 0 -8.797973642501175e+17
Gr46_re_1_4 0 s1 x46_re_a4 0 -1.9850484916123197e+19
Gr46_im_1_4 0 s1 x46_im_a4 0 -1.2955845755075713e+19
Gr47_re_1_4 0 s1 x47_re_a4 0 1.6042972042410496e+19
Gr47_im_1_4 0 s1 x47_im_a4 0 -8.570855107273806e+18
Gr48_re_1_4 0 s1 x48_re_a4 0 9.480245375397319e+18
Gr48_im_1_4 0 s1 x48_im_a4 0 -9.975588760350086e+17
Gr49_re_1_4 0 s1 x49_re_a4 0 5.648382818930734e+18
Gr49_im_1_4 0 s1 x49_im_a4 0 2.1912752868871841e+18
Gr50_re_1_4 0 s1 x50_re_a4 0 -2.6937039253036846e+18
Gr50_im_1_4 0 s1 x50_im_a4 0 1.6081613635879698e+18
Gr51_re_1_4 0 s1 x51_re_a4 0 -7.997077352573212e+18
Gr51_im_1_4 0 s1 x51_im_a4 0 7.969127027739398e+17
Gr52_re_1_4 0 s1 x52_re_a4 0 -8.929411174759552e+18
Gr52_im_1_4 0 s1 x52_im_a4 0 6.257152924425884e+17
Gr53_re_1_4 0 s1 x53_re_a4 0 -1.0804187951132678e+19
Gr53_im_1_4 0 s1 x53_im_a4 0 3.233559403653263e+17
Gr54_re_1_4 0 s1 x54_re_a4 0 -1.1528684205902342e+19
Gr54_im_1_4 0 s1 x54_im_a4 0 2.2579268686296906e+17
Gr55_re_1_4 0 s1 x55_re_a4 0 -1.1877168545442712e+19
Gr55_im_1_4 0 s1 x55_im_a4 0 1.399098713142896e+17
Gr56_re_1_4 0 s1 x56_re_a4 0 -1.1098478464967225e+19
Gr56_im_1_4 0 s1 x56_im_a4 0 7.736439648113117e+16
Gr57_re_1_4 0 s1 x57_re_a4 0 -3.623223115703152e+18
Gr57_im_1_4 0 s1 x57_im_a4 0 1.3315695675253878e+16
Gr58_re_1_4 0 s1 x58_re_a4 0 -8.260549379924099e+18
Gr58_im_1_4 0 s1 x58_im_a4 0 3.63909225627638e+16
Gr59_re_1_4 0 s1 x59_re_a4 0 -1.9279970306418084e+16
Gr59_im_1_4 0 s1 x59_im_a4 0 279417558451108.03
Gr60_re_1_4 0 s1 x60_re_a4 0 -6.106066190576741e+17
Gr60_im_1_4 0 s1 x60_im_a4 0 3077632630602136.5
*
* State networks driven by port 1
Cx1_re_a1 x1_re_a1 0 1.0
Gx1_re_a1 0 x1_re_a1 p1 0 0.1414213562373095
Fx1_re_a1 0 x1_re_a1 V1 7.0710678118654755
Rp1_re_re_a1 0 x1_re_a1 1.9339271087549648e-10
Gp1_re_im_a1 0 x1_re_a1 x1_im_a1 0 347079283315.0595
Cx1_im_a1 x1_im_a1 0 1.0
Gp1_im_re_a1 0 x1_im_a1 x1_re_a1 0 -347079283315.0595
Rp1_im_im_a1 0 x1_im_a1 1.9339271087549648e-10
Cx2_re_a1 x2_re_a1 0 1.0
Gx2_re_a1 0 x2_re_a1 p1 0 0.1414213562373095
Fx2_re_a1 0 x2_re_a1 V1 7.0710678118654755
Rp2_re_re_a1 0 x2_re_a1 5.691004706881973e-10
Gp2_re_im_a1 0 x2_re_a1 x2_im_a1 0 303418375537.5658
Cx2_im_a1 x2_im_a1 0 1.0
Gp2_im_re_a1 0 x2_im_a1 x2_re_a1 0 -303418375537.5658
Rp2_im_im_a1 0 x2_im_a1 5.691004706881973e-10
Cx3_re_a1 x3_re_a1 0 1.0
Gx3_re_a1 0 x3_re_a1 p1 0 0.1414213562373095
Fx3_re_a1 0 x3_re_a1 V1 7.0710678118654755
Rp3_re_re_a1 0 x3_re_a1 5.362465275255059e-10
Gp3_re_im_a1 0 x3_re_a1 x3_im_a1 0 299764945822.76807
Cx3_im_a1 x3_im_a1 0 1.0
Gp3_im_re_a1 0 x3_im_a1 x3_re_a1 0 -299764945822.76807
Rp3_im_im_a1 0 x3_im_a1 5.362465275255059e-10
Cx4_re_a1 x4_re_a1 0 1.0
Gx4_re_a1 0 x4_re_a1 p1 0 0.1414213562373095
Fx4_re_a1 0 x4_re_a1 V1 7.0710678118654755
Rp4_re_re_a1 0 x4_re_a1 5.651020630265948e-10
Gp4_re_im_a1 0 x4_re_a1 x4_im_a1 0 295780770455.4801
Cx4_im_a1 x4_im_a1 0 1.0
Gp4_im_re_a1 0 x4_im_a1 x4_re_a1 0 -295780770455.4801
Rp4_im_im_a1 0 x4_im_a1 5.651020630265948e-10
Cx5_re_a1 x5_re_a1 0 1.0
Gx5_re_a1 0 x5_re_a1 p1 0 0.1414213562373095
Fx5_re_a1 0 x5_re_a1 V1 7.0710678118654755
Rp5_re_re_a1 0 x5_re_a1 4.4583648371353355e-11
Gp5_re_im_a1 0 x5_re_a1 x5_im_a1 0 280184551048.1205
Cx5_im_a1 x5_im_a1 0 1.0
Gp5_im_re_a1 0 x5_im_a1 x5_re_a1 0 -280184551048.1205
Rp5_im_im_a1 0 x5_im_a1 4.4583648371353355e-11
Cx6_re_a1 x6_re_a1 0 1.0
Gx6_re_a1 0 x6_re_a1 p1 0 0.1414213562373095
Fx6_re_a1 0 x6_re_a1 V1 7.0710678118654755
Rp6_re_re_a1 0 x6_re_a1 9.027710283976132e-10
Gp6_re_im_a1 0 x6_re_a1 x6_im_a1 0 284797609898.4314
Cx6_im_a1 x6_im_a1 0 1.0
Gp6_im_re_a1 0 x6_im_a1 x6_re_a1 0 -284797609898.4314
Rp6_im_im_a1 0 x6_im_a1 9.027710283976132e-10
Cx7_re_a1 x7_re_a1 0 1.0
Gx7_re_a1 0 x7_re_a1 p1 0 0.1414213562373095
Fx7_re_a1 0 x7_re_a1 V1 7.0710678118654755
Rp7_re_re_a1 0 x7_re_a1 7.771258315741444e-10
Gp7_re_im_a1 0 x7_re_a1 x7_im_a1 0 280937443543.525
Cx7_im_a1 x7_im_a1 0 1.0
Gp7_im_re_a1 0 x7_im_a1 x7_re_a1 0 -280937443543.525
Rp7_im_im_a1 0 x7_im_a1 7.771258315741444e-10
Cx8_re_a1 x8_re_a1 0 1.0
Gx8_re_a1 0 x8_re_a1 p1 0 0.1414213562373095
Fx8_re_a1 0 x8_re_a1 V1 7.0710678118654755
Rp8_re_re_a1 0 x8_re_a1 1.3252660304487296e-09
Gp8_re_im_a1 0 x8_re_a1 x8_im_a1 0 269390760843.16248
Cx8_im_a1 x8_im_a1 0 1.0
Gp8_im_re_a1 0 x8_im_a1 x8_re_a1 0 -269390760843.16248
Rp8_im_im_a1 0 x8_im_a1 1.3252660304487296e-09
Cx9_re_a1 x9_re_a1 0 1.0
Gx9_re_a1 0 x9_re_a1 p1 0 0.1414213562373095
Fx9_re_a1 0 x9_re_a1 V1 7.0710678118654755
Rp9_re_re_a1 0 x9_re_a1 8.837487410164448e-10
Gp9_re_im_a1 0 x9_re_a1 x9_im_a1 0 260736146261.56058
Cx9_im_a1 x9_im_a1 0 1.0
Gp9_im_re_a1 0 x9_im_a1 x9_re_a1 0 -260736146261.56058
Rp9_im_im_a1 0 x9_im_a1 8.837487410164448e-10
Cx10_re_a1 x10_re_a1 0 1.0
Gx10_re_a1 0 x10_re_a1 p1 0 0.1414213562373095
Fx10_re_a1 0 x10_re_a1 V1 7.0710678118654755
Rp10_re_re_a1 0 x10_re_a1 7.74337520639369e-10
Gp10_re_im_a1 0 x10_re_a1 x10_im_a1 0 246291422182.96008
Cx10_im_a1 x10_im_a1 0 1.0
Gp10_im_re_a1 0 x10_im_a1 x10_re_a1 0 -246291422182.96008
Rp10_im_im_a1 0 x10_im_a1 7.74337520639369e-10
Cx11_re_a1 x11_re_a1 0 1.0
Gx11_re_a1 0 x11_re_a1 p1 0 0.1414213562373095
Fx11_re_a1 0 x11_re_a1 V1 7.0710678118654755
Rp11_re_re_a1 0 x11_re_a1 8.390860458298588e-10
Gp11_re_im_a1 0 x11_re_a1 x11_im_a1 0 242228737451.13144
Cx11_im_a1 x11_im_a1 0 1.0
Gp11_im_re_a1 0 x11_im_a1 x11_re_a1 0 -242228737451.13144
Rp11_im_im_a1 0 x11_im_a1 8.390860458298588e-10
Cx12_re_a1 x12_re_a1 0 1.0
Gx12_re_a1 0 x12_re_a1 p1 0 0.1414213562373095
Fx12_re_a1 0 x12_re_a1 V1 7.0710678118654755
Rp12_re_re_a1 0 x12_re_a1 4.4656692854153325e-10
Gp12_re_im_a1 0 x12_re_a1 x12_im_a1 0 236640156802.20322
Cx12_im_a1 x12_im_a1 0 1.0
Gp12_im_re_a1 0 x12_im_a1 x12_re_a1 0 -236640156802.20322
Rp12_im_im_a1 0 x12_im_a1 4.4656692854153325e-10
Cx13_re_a1 x13_re_a1 0 1.0
Gx13_re_a1 0 x13_re_a1 p1 0 0.1414213562373095
Fx13_re_a1 0 x13_re_a1 V1 7.0710678118654755
Rp13_re_re_a1 0 x13_re_a1 6.602787100602715e-10
Gp13_re_im_a1 0 x13_re_a1 x13_im_a1 0 229310531843.11926
Cx13_im_a1 x13_im_a1 0 1.0
Gp13_im_re_a1 0 x13_im_a1 x13_re_a1 0 -229310531843.11926
Rp13_im_im_a1 0 x13_im_a1 6.602787100602715e-10
Cx14_re_a1 x14_re_a1 0 1.0
Gx14_re_a1 0 x14_re_a1 p1 0 0.1414213562373095
Fx14_re_a1 0 x14_re_a1 V1 7.0710678118654755
Rp14_re_re_a1 0 x14_re_a1 6.683832237932593e-10
Gp14_re_im_a1 0 x14_re_a1 x14_im_a1 0 221343536942.1764
Cx14_im_a1 x14_im_a1 0 1.0
Gp14_im_re_a1 0 x14_im_a1 x14_re_a1 0 -221343536942.1764
Rp14_im_im_a1 0 x14_im_a1 6.683832237932593e-10
Cx15_re_a1 x15_re_a1 0 1.0
Gx15_re_a1 0 x15_re_a1 p1 0 0.1414213562373095
Fx15_re_a1 0 x15_re_a1 V1 7.0710678118654755
Rp15_re_re_a1 0 x15_re_a1 7.821256797324849e-10
Gp15_re_im_a1 0 x15_re_a1 x15_im_a1 0 216900169045.56696
Cx15_im_a1 x15_im_a1 0 1.0
Gp15_im_re_a1 0 x15_im_a1 x15_re_a1 0 -216900169045.56696
Rp15_im_im_a1 0 x15_im_a1 7.821256797324849e-10
Cx16_re_a1 x16_re_a1 0 1.0
Gx16_re_a1 0 x16_re_a1 p1 0 0.1414213562373095
Fx16_re_a1 0 x16_re_a1 V1 7.0710678118654755
Rp16_re_re_a1 0 x16_re_a1 7.830440984431804e-10
Gp16_re_im_a1 0 x16_re_a1 x16_im_a1 0 205989675376.3724
Cx16_im_a1 x16_im_a1 0 1.0
Gp16_im_re_a1 0 x16_im_a1 x16_re_a1 0 -205989675376.3724
Rp16_im_im_a1 0 x16_im_a1 7.830440984431804e-10
Cx17_re_a1 x17_re_a1 0 1.0
Gx17_re_a1 0 x17_re_a1 p1 0 0.1414213562373095
Fx17_re_a1 0 x17_re_a1 V1 7.0710678118654755
Rp17_re_re_a1 0 x17_re_a1 3.6596596885047425e-10
Gp17_re_im_a1 0 x17_re_a1 x17_im_a1 0 200356736984.54144
Cx17_im_a1 x17_im_a1 0 1.0
Gp17_im_re_a1 0 x17_im_a1 x17_re_a1 0 -200356736984.54144
Rp17_im_im_a1 0 x17_im_a1 3.6596596885047425e-10
Cx18_re_a1 x18_re_a1 0 1.0
Gx18_re_a1 0 x18_re_a1 p1 0 0.1414213562373095
Fx18_re_a1 0 x18_re_a1 V1 7.0710678118654755
Rp18_re_re_a1 0 x18_re_a1 4.584479098871507e-10
Gp18_re_im_a1 0 x18_re_a1 x18_im_a1 0 194828352286.79108
Cx18_im_a1 x18_im_a1 0 1.0
Gp18_im_re_a1 0 x18_im_a1 x18_re_a1 0 -194828352286.79108
Rp18_im_im_a1 0 x18_im_a1 4.584479098871507e-10
Cx19_re_a1 x19_re_a1 0 1.0
Gx19_re_a1 0 x19_re_a1 p1 0 0.1414213562373095
Fx19_re_a1 0 x19_re_a1 V1 7.0710678118654755
Rp19_re_re_a1 0 x19_re_a1 3.2577500493070084e-10
Gp19_re_im_a1 0 x19_re_a1 x19_im_a1 0 187933840477.96106
Cx19_im_a1 x19_im_a1 0 1.0
Gp19_im_re_a1 0 x19_im_a1 x19_re_a1 0 -187933840477.96106
Rp19_im_im_a1 0 x19_im_a1 3.2577500493070084e-10
Cx20_re_a1 x20_re_a1 0 1.0
Gx20_re_a1 0 x20_re_a1 p1 0 0.1414213562373095
Fx20_re_a1 0 x20_re_a1 V1 7.0710678118654755
Rp20_re_re_a1 0 x20_re_a1 3.7030670747264964e-10
Gp20_re_im_a1 0 x20_re_a1 x20_im_a1 0 182988642847.68027
Cx20_im_a1 x20_im_a1 0 1.0
Gp20_im_re_a1 0 x20_im_a1 x20_re_a1 0 -182988642847.68027
Rp20_im_im_a1 0 x20_im_a1 3.7030670747264964e-10
Cx21_re_a1 x21_re_a1 0 1.0
Gx21_re_a1 0 x21_re_a1 p1 0 0.1414213562373095
Fx21_re_a1 0 x21_re_a1 V1 7.0710678118654755
Rp21_re_re_a1 0 x21_re_a1 4.088062182753204e-10
Gp21_re_im_a1 0 x21_re_a1 x21_im_a1 0 177633712933.48953
Cx21_im_a1 x21_im_a1 0 1.0
Gp21_im_re_a1 0 x21_im_a1 x21_re_a1 0 -177633712933.48953
Rp21_im_im_a1 0 x21_im_a1 4.088062182753204e-10
Cx22_re_a1 x22_re_a1 0 1.0
Gx22_re_a1 0 x22_re_a1 p1 0 0.1414213562373095
Fx22_re_a1 0 x22_re_a1 V1 7.0710678118654755
Rp22_re_re_a1 0 x22_re_a1 3.9909194915050626e-10
Gp22_re_im_a1 0 x22_re_a1 x22_im_a1 0 170516011194.32175
Cx22_im_a1 x22_im_a1 0 1.0
Gp22_im_re_a1 0 x22_im_a1 x22_re_a1 0 -170516011194.32175
Rp22_im_im_a1 0 x22_im_a1 3.9909194915050626e-10
Cx23_re_a1 x23_re_a1 0 1.0
Gx23_re_a1 0 x23_re_a1 p1 0 0.1414213562373095
Fx23_re_a1 0 x23_re_a1 V1 7.0710678118654755
Rp23_re_re_a1 0 x23_re_a1 3.5380163711038947e-10
Gp23_re_im_a1 0 x23_re_a1 x23_im_a1 0 164953816321.0323
Cx23_im_a1 x23_im_a1 0 1.0
Gp23_im_re_a1 0 x23_im_a1 x23_re_a1 0 -164953816321.0323
Rp23_im_im_a1 0 x23_im_a1 3.5380163711038947e-10
Cx24_re_a1 x24_re_a1 0 1.0
Gx24_re_a1 0 x24_re_a1 p1 0 0.1414213562373095
Fx24_re_a1 0 x24_re_a1 V1 7.0710678118654755
Rp24_re_re_a1 0 x24_re_a1 5.039130565519937e-10
Gp24_re_im_a1 0 x24_re_a1 x24_im_a1 0 159173864190.63727
Cx24_im_a1 x24_im_a1 0 1.0
Gp24_im_re_a1 0 x24_im_a1 x24_re_a1 0 -159173864190.63727
Rp24_im_im_a1 0 x24_im_a1 5.039130565519937e-10
Cx25_re_a1 x25_re_a1 0 1.0
Gx25_re_a1 0 x25_re_a1 p1 0 0.1414213562373095
Fx25_re_a1 0 x25_re_a1 V1 7.0710678118654755
Rp25_re_re_a1 0 x25_re_a1 4.289339569151169e-10
Gp25_re_im_a1 0 x25_re_a1 x25_im_a1 0 152473894102.3021
Cx25_im_a1 x25_im_a1 0 1.0
Gp25_im_re_a1 0 x25_im_a1 x25_re_a1 0 -152473894102.3021
Rp25_im_im_a1 0 x25_im_a1 4.289339569151169e-10
Cx26_re_a1 x26_re_a1 0 1.0
Gx26_re_a1 0 x26_re_a1 p1 0 0.1414213562373095
Fx26_re_a1 0 x26_re_a1 V1 7.0710678118654755
Rp26_re_re_a1 0 x26_re_a1 5.604106708721165e-10
Gp26_re_im_a1 0 x26_re_a1 x26_im_a1 0 143458007374.04828
Cx26_im_a1 x26_im_a1 0 1.0
Gp26_im_re_a1 0 x26_im_a1 x26_re_a1 0 -143458007374.04828
Rp26_im_im_a1 0 x26_im_a1 5.604106708721165e-10
Cx27_re_a1 x27_re_a1 0 1.0
Gx27_re_a1 0 x27_re_a1 p1 0 0.1414213562373095
Fx27_re_a1 0 x27_re_a1 V1 7.0710678118654755
Rp27_re_re_a1 0 x27_re_a1 4.0415824417463693e-10
Gp27_re_im_a1 0 x27_re_a1 x27_im_a1 0 139191009718.3968
Cx27_im_a1 x27_im_a1 0 1.0
Gp27_im_re_a1 0 x27_im_a1 x27_re_a1 0 -139191009718.3968
Rp27_im_im_a1 0 x27_im_a1 4.0415824417463693e-10
Cx28_re_a1 x28_re_a1 0 1.0
Gx28_re_a1 0 x28_re_a1 p1 0 0.1414213562373095
Fx28_re_a1 0 x28_re_a1 V1 7.0710678118654755
Rp28_re_re_a1 0 x28_re_a1 5.515497777837109e-10
Gp28_re_im_a1 0 x28_re_a1 x28_im_a1 0 135717785993.89098
Cx28_im_a1 x28_im_a1 0 1.0
Gp28_im_re_a1 0 x28_im_a1 x28_re_a1 0 -135717785993.89098
Rp28_im_im_a1 0 x28_im_a1 5.515497777837109e-10
Cx29_re_a1 x29_re_a1 0 1.0
Gx29_re_a1 0 x29_re_a1 p1 0 0.1414213562373095
Fx29_re_a1 0 x29_re_a1 V1 7.0710678118654755
Rp29_re_re_a1 0 x29_re_a1 5.385911467068673e-10
Gp29_re_im_a1 0 x29_re_a1 x29_im_a1 0 130198859531.93167
Cx29_im_a1 x29_im_a1 0 1.0
Gp29_im_re_a1 0 x29_im_a1 x29_re_a1 0 -130198859531.93167
Rp29_im_im_a1 0 x29_im_a1 5.385911467068673e-10
Cx30_re_a1 x30_re_a1 0 1.0
Gx30_re_a1 0 x30_re_a1 p1 0 0.1414213562373095
Fx30_re_a1 0 x30_re_a1 V1 7.0710678118654755
Rp30_re_re_a1 0 x30_re_a1 1.293631499869189e-10
Gp30_re_im_a1 0 x30_re_a1 x30_im_a1 0 125026933526.9245
Cx30_im_a1 x30_im_a1 0 1.0
Gp30_im_re_a1 0 x30_im_a1 x30_re_a1 0 -125026933526.9245
Rp30_im_im_a1 0 x30_im_a1 1.293631499869189e-10
Cx31_re_a1 x31_re_a1 0 1.0
Gx31_re_a1 0 x31_re_a1 p1 0 0.1414213562373095
Fx31_re_a1 0 x31_re_a1 V1 7.0710678118654755
Rp31_re_re_a1 0 x31_re_a1 4.4598309986159816e-10
Gp31_re_im_a1 0 x31_re_a1 x31_im_a1 0 125249512856.41823
Cx31_im_a1 x31_im_a1 0 1.0
Gp31_im_re_a1 0 x31_im_a1 x31_re_a1 0 -125249512856.41823
Rp31_im_im_a1 0 x31_im_a1 4.4598309986159816e-10
Cx32_re_a1 x32_re_a1 0 1.0
Gx32_re_a1 0 x32_re_a1 p1 0 0.1414213562373095
Fx32_re_a1 0 x32_re_a1 V1 7.0710678118654755
Rp32_re_re_a1 0 x32_re_a1 6.806449337893251e-10
Gp32_re_im_a1 0 x32_re_a1 x32_im_a1 0 114377525421.56393
Cx32_im_a1 x32_im_a1 0 1.0
Gp32_im_re_a1 0 x32_im_a1 x32_re_a1 0 -114377525421.56393
Rp32_im_im_a1 0 x32_im_a1 6.806449337893251e-10
Cx33_re_a1 x33_re_a1 0 1.0
Gx33_re_a1 0 x33_re_a1 p1 0 0.1414213562373095
Fx33_re_a1 0 x33_re_a1 V1 7.0710678118654755
Rp33_re_re_a1 0 x33_re_a1 6.827975557481133e-10
Gp33_re_im_a1 0 x33_re_a1 x33_im_a1 0 109880322668.63147
Cx33_im_a1 x33_im_a1 0 1.0
Gp33_im_re_a1 0 x33_im_a1 x33_re_a1 0 -109880322668.63147
Rp33_im_im_a1 0 x33_im_a1 6.827975557481133e-10
Cx34_re_a1 x34_re_a1 0 1.0
Gx34_re_a1 0 x34_re_a1 p1 0 0.1414213562373095
Fx34_re_a1 0 x34_re_a1 V1 7.0710678118654755
Rp34_re_re_a1 0 x34_re_a1 6.414613283370872e-10
Gp34_re_im_a1 0 x34_re_a1 x34_im_a1 0 100363561795.05267
Cx34_im_a1 x34_im_a1 0 1.0
Gp34_im_re_a1 0 x34_im_a1 x34_re_a1 0 -100363561795.05267
Rp34_im_im_a1 0 x34_im_a1 6.414613283370872e-10
Cx35_re_a1 x35_re_a1 0 1.0
Gx35_re_a1 0 x35_re_a1 p1 0 0.1414213562373095
Fx35_re_a1 0 x35_re_a1 V1 7.0710678118654755
Rp35_re_re_a1 0 x35_re_a1 5.255745869778509e-10
Gp35_re_im_a1 0 x35_re_a1 x35_im_a1 0 95922025504.53201
Cx35_im_a1 x35_im_a1 0 1.0
Gp35_im_re_a1 0 x35_im_a1 x35_re_a1 0 -95922025504.53201
Rp35_im_im_a1 0 x35_im_a1 5.255745869778509e-10
Cx36_re_a1 x36_re_a1 0 1.0
Gx36_re_a1 0 x36_re_a1 p1 0 0.1414213562373095
Fx36_re_a1 0 x36_re_a1 V1 7.0710678118654755
Rp36_re_re_a1 0 x36_re_a1 4.701845418472811e-10
Gp36_re_im_a1 0 x36_re_a1 x36_im_a1 0 91827204426.0559
Cx36_im_a1 x36_im_a1 0 1.0
Gp36_im_re_a1 0 x36_im_a1 x36_re_a1 0 -91827204426.0559
Rp36_im_im_a1 0 x36_im_a1 4.701845418472811e-10
Cx37_re_a1 x37_re_a1 0 1.0
Gx37_re_a1 0 x37_re_a1 p1 0 0.1414213562373095
Fx37_re_a1 0 x37_re_a1 V1 7.0710678118654755
Rp37_re_re_a1 0 x37_re_a1 5.1986573840207194e-11
Gp37_re_im_a1 0 x37_re_a1 x37_im_a1 0 72397845044.52003
Cx37_im_a1 x37_im_a1 0 1.0
Gp37_im_re_a1 0 x37_im_a1 x37_re_a1 0 -72397845044.52003
Rp37_im_im_a1 0 x37_im_a1 5.1986573840207194e-11
Cx38_re_a1 x38_re_a1 0 1.0
Gx38_re_a1 0 x38_re_a1 p1 0 0.1414213562373095
Fx38_re_a1 0 x38_re_a1 V1 7.0710678118654755
Rp38_re_re_a1 0 x38_re_a1 6.266691087283841e-10
Gp38_re_im_a1 0 x38_re_a1 x38_im_a1 0 87242951630.81523
Cx38_im_a1 x38_im_a1 0 1.0
Gp38_im_re_a1 0 x38_im_a1 x38_re_a1 0 -87242951630.81523
Rp38_im_im_a1 0 x38_im_a1 6.266691087283841e-10
Cx39_re_a1 x39_re_a1 0 1.0
Gx39_re_a1 0 x39_re_a1 p1 0 0.1414213562373095
Fx39_re_a1 0 x39_re_a1 V1 7.0710678118654755
Rp39_re_re_a1 0 x39_re_a1 5.234864343640884e-10
Gp39_re_im_a1 0 x39_re_a1 x39_im_a1 0 82858757195.85092
Cx39_im_a1 x39_im_a1 0 1.0
Gp39_im_re_a1 0 x39_im_a1 x39_re_a1 0 -82858757195.85092
Rp39_im_im_a1 0 x39_im_a1 5.234864343640884e-10
Cx40_re_a1 x40_re_a1 0 1.0
Gx40_re_a1 0 x40_re_a1 p1 0 0.1414213562373095
Fx40_re_a1 0 x40_re_a1 V1 7.0710678118654755
Rp40_re_re_a1 0 x40_re_a1 5.871156006436874e-10
Gp40_re_im_a1 0 x40_re_a1 x40_im_a1 0 78507674910.57098
Cx40_im_a1 x40_im_a1 0 1.0
Gp40_im_re_a1 0 x40_im_a1 x40_re_a1 0 -78507674910.57098
Rp40_im_im_a1 0 x40_im_a1 5.871156006436874e-10
Cx41_re_a1 x41_re_a1 0 1.0
Gx41_re_a1 0 x41_re_a1 p1 0 0.1414213562373095
Fx41_re_a1 0 x41_re_a1 V1 7.0710678118654755
Rp41_re_re_a1 0 x41_re_a1 7.362920812502898e-10
Gp41_re_im_a1 0 x41_re_a1 x41_im_a1 0 53898762948.71844
Cx41_im_a1 x41_im_a1 0 1.0
Gp41_im_re_a1 0 x41_im_a1 x41_re_a1 0 -53898762948.71844
Rp41_im_im_a1 0 x41_im_a1 7.362920812502898e-10
Cx42_re_a1 x42_re_a1 0 1.0
Gx42_re_a1 0 x42_re_a1 p1 0 0.1414213562373095
Fx42_re_a1 0 x42_re_a1 V1 7.0710678118654755
Rp42_re_re_a1 0 x42_re_a1 6.83072510187094e-10
Gp42_re_im_a1 0 x42_re_a1 x42_im_a1 0 49596203552.090675
Cx42_im_a1 x42_im_a1 0 1.0
Gp42_im_re_a1 0 x42_im_a1 x42_re_a1 0 -49596203552.090675
Rp42_im_im_a1 0 x42_im_a1 6.83072510187094e-10
Cx43_re_a1 x43_re_a1 0 1.0
Gx43_re_a1 0 x43_re_a1 p1 0 0.1414213562373095
Fx43_re_a1 0 x43_re_a1 V1 7.0710678118654755
Rp43_re_re_a1 0 x43_re_a1 7.886851854703573e-10
Gp43_re_im_a1 0 x43_re_a1 x43_im_a1 0 33914448806.74464
Cx43_im_a1 x43_im_a1 0 1.0
Gp43_im_re_a1 0 x43_im_a1 x43_re_a1 0 -33914448806.74464
Rp43_im_im_a1 0 x43_im_a1 7.886851854703573e-10
Cx44_re_a1 x44_re_a1 0 1.0
Gx44_re_a1 0 x44_re_a1 p1 0 0.1414213562373095
Fx44_re_a1 0 x44_re_a1 V1 7.0710678118654755
Rp44_re_re_a1 0 x44_re_a1 6.90773635036418e-10
Gp44_re_im_a1 0 x44_re_a1 x44_im_a1 0 28461055845.680824
Cx44_im_a1 x44_im_a1 0 1.0
Gp44_im_re_a1 0 x44_im_a1 x44_re_a1 0 -28461055845.680824
Rp44_im_im_a1 0 x44_im_a1 6.90773635036418e-10
Cx45_re_a1 x45_re_a1 0 1.0
Gx45_re_a1 0 x45_re_a1 p1 0 0.1414213562373095
Fx45_re_a1 0 x45_re_a1 V1 7.0710678118654755
Rp45_re_re_a1 0 x45_re_a1 6.80191910067349e-10
Gp45_re_im_a1 0 x45_re_a1 x45_im_a1 0 24097859368.009228
Cx45_im_a1 x45_im_a1 0 1.0
Gp45_im_re_a1 0 x45_im_a1 x45_re_a1 0 -24097859368.009228
Rp45_im_im_a1 0 x45_im_a1 6.80191910067349e-10
Cx46_re_a1 x46_re_a1 0 1.0
Gx46_re_a1 0 x46_re_a1 p1 0 0.1414213562373095
Fx46_re_a1 0 x46_re_a1 V1 7.0710678118654755
Rp46_re_re_a1 0 x46_re_a1 3.3632515940909853e-10
Gp46_re_im_a1 0 x46_re_a1 x46_im_a1 0 17535003925.97815
Cx46_im_a1 x46_im_a1 0 1.0
Gp46_im_re_a1 0 x46_im_a1 x46_re_a1 0 -17535003925.97815
Rp46_im_im_a1 0 x46_im_a1 3.3632515940909853e-10
Cx47_re_a1 x47_re_a1 0 1.0
Gx47_re_a1 0 x47_re_a1 p1 0 0.1414213562373095
Fx47_re_a1 0 x47_re_a1 V1 7.0710678118654755
Rp47_re_re_a1 0 x47_re_a1 9.629414892146456e-10
Gp47_re_im_a1 0 x47_re_a1 x47_im_a1 0 11715090574.045237
Cx47_im_a1 x47_im_a1 0 1.0
Gp47_im_re_a1 0 x47_im_a1 x47_re_a1 0 -11715090574.045237
Rp47_im_im_a1 0 x47_im_a1 9.629414892146456e-10
Cx48_re_a1 x48_re_a1 0 1.0
Gx48_re_a1 0 x48_re_a1 p1 0 0.1414213562373095
Fx48_re_a1 0 x48_re_a1 V1 7.0710678118654755
Rp48_re_re_a1 0 x48_re_a1 8.037389283921146e-10
Gp48_re_im_a1 0 x48_re_a1 x48_im_a1 0 8411555387.1175995
Cx48_im_a1 x48_im_a1 0 1.0
Gp48_im_re_a1 0 x48_im_a1 x48_re_a1 0 -8411555387.1175995
Rp48_im_im_a1 0 x48_im_a1 8.037389283921146e-10
Cx49_re_a1 x49_re_a1 0 1.0
Gx49_re_a1 0 x49_re_a1 p1 0 0.1414213562373095
Fx49_re_a1 0 x49_re_a1 V1 7.0710678118654755
Rp49_re_re_a1 0 x49_re_a1 2.3953032926638584e-09
Gp49_re_im_a1 0 x49_re_a1 x49_im_a1 0 7281971191.968741
Cx49_im_a1 x49_im_a1 0 1.0
Gp49_im_re_a1 0 x49_im_a1 x49_re_a1 0 -7281971191.968741
Rp49_im_im_a1 0 x49_im_a1 2.3953032926638584e-09
Cx50_re_a1 x50_re_a1 0 1.0
Gx50_re_a1 0 x50_re_a1 p1 0 0.1414213562373095
Fx50_re_a1 0 x50_re_a1 V1 7.0710678118654755
Rp50_re_re_a1 0 x50_re_a1 9.291538099627055e-09
Gp50_re_im_a1 0 x50_re_a1 x50_im_a1 0 5485192888.061847
Cx50_im_a1 x50_im_a1 0 1.0
Gp50_im_re_a1 0 x50_im_a1 x50_re_a1 0 -5485192888.061847
Rp50_im_im_a1 0 x50_im_a1 9.291538099627055e-09
Cx51_re_a1 x51_re_a1 0 1.0
Gx51_re_a1 0 x51_re_a1 p1 0 0.1414213562373095
Fx51_re_a1 0 x51_re_a1 V1 7.0710678118654755
Rp51_re_re_a1 0 x51_re_a1 1.1361341983747998e-08
Gp51_re_im_a1 0 x51_re_a1 x51_im_a1 0 4208225203.7586317
Cx51_im_a1 x51_im_a1 0 1.0
Gp51_im_re_a1 0 x51_im_a1 x51_re_a1 0 -4208225203.7586317
Rp51_im_im_a1 0 x51_im_a1 1.1361341983747998e-08
Cx52_re_a1 x52_re_a1 0 1.0
Gx52_re_a1 0 x52_re_a1 p1 0 0.1414213562373095
Fx52_re_a1 0 x52_re_a1 V1 7.0710678118654755
Rp52_re_re_a1 0 x52_re_a1 6.593416593325721e-09
Gp52_re_im_a1 0 x52_re_a1 x52_im_a1 0 3907713961.770896
Cx52_im_a1 x52_im_a1 0 1.0
Gp52_im_re_a1 0 x52_im_a1 x52_re_a1 0 -3907713961.770896
Rp52_im_im_a1 0 x52_im_a1 6.593416593325721e-09
Cx53_re_a1 x53_re_a1 0 1.0
Gx53_re_a1 0 x53_re_a1 p1 0 0.1414213562373095
Fx53_re_a1 0 x53_re_a1 V1 7.0710678118654755
Rp53_re_re_a1 0 x53_re_a1 4.598865760619702e-09
Gp53_re_im_a1 0 x53_re_a1 x53_im_a1 0 3138989640.311349
Cx53_im_a1 x53_im_a1 0 1.0
Gp53_im_re_a1 0 x53_im_a1 x53_re_a1 0 -3138989640.311349
Rp53_im_im_a1 0 x53_im_a1 4.598865760619702e-09
Cx54_re_a1 x54_re_a1 0 1.0
Gx54_re_a1 0 x54_re_a1 p1 0 0.1414213562373095
Fx54_re_a1 0 x54_re_a1 V1 7.0710678118654755
Rp54_re_re_a1 0 x54_re_a1 5.013329113974378e-09
Gp54_re_im_a1 0 x54_re_a1 x54_im_a1 0 2763239017.283009
Cx54_im_a1 x54_im_a1 0 1.0
Gp54_im_re_a1 0 x54_im_a1 x54_re_a1 0 -2763239017.283009
Rp54_im_im_a1 0 x54_im_a1 5.013329113974378e-09
Cx55_re_a1 x55_re_a1 0 1.0
Gx55_re_a1 0 x55_re_a1 p1 0 0.1414213562373095
Fx55_re_a1 0 x55_re_a1 V1 7.0710678118654755
Rp55_re_re_a1 0 x55_re_a1 5.489391819401233e-09
Gp55_re_im_a1 0 x55_re_a1 x55_im_a1 0 2337692824.826442
Cx55_im_a1 x55_im_a1 0 1.0
Gp55_im_re_a1 0 x55_im_a1 x55_re_a1 0 -2337692824.826442
Rp55_im_im_a1 0 x55_im_a1 5.489391819401233e-09
Cx56_re_a1 x56_re_a1 0 1.0
Gx56_re_a1 0 x56_re_a1 p1 0 0.1414213562373095
Fx56_re_a1 0 x56_re_a1 V1 7.0710678118654755
Rp56_re_re_a1 0 x56_re_a1 5.715836849677958e-09
Gp56_re_im_a1 0 x56_re_a1 x56_im_a1 0 1907462400.4905782
Cx56_im_a1 x56_im_a1 0 1.0
Gp56_im_re_a1 0 x56_im_a1 x56_re_a1 0 -1907462400.4905782
Rp56_im_im_a1 0 x56_im_a1 5.715836849677958e-09
Cx57_re_a1 x57_re_a1 0 1.0
Gx57_re_a1 0 x57_re_a1 p1 0 0.1414213562373095
Fx57_re_a1 0 x57_re_a1 V1 7.0710678118654755
Rp57_re_re_a1 0 x57_re_a1 5.740354751724126e-09
Gp57_re_im_a1 0 x57_re_a1 x57_im_a1 0 1043629713.8561413
Cx57_im_a1 x57_im_a1 0 1.0
Gp57_im_re_a1 0 x57_im_a1 x57_re_a1 0 -1043629713.8561413
Rp57_im_im_a1 0 x57_im_a1 5.740354751724126e-09
Cx58_re_a1 x58_re_a1 0 1.0
Gx58_re_a1 0 x58_re_a1 p1 0 0.1414213562373095
Fx58_re_a1 0 x58_re_a1 V1 7.0710678118654755
Rp58_re_re_a1 0 x58_re_a1 5.783268392817006e-09
Gp58_re_im_a1 0 x58_re_a1 x58_im_a1 0 1474144465.2759433
Cx58_im_a1 x58_im_a1 0 1.0
Gp58_im_re_a1 0 x58_im_a1 x58_re_a1 0 -1474144465.2759433
Rp58_im_im_a1 0 x58_im_a1 5.783268392817006e-09
Cx59_re_a1 x59_re_a1 0 1.0
Gx59_re_a1 0 x59_re_a1 p1 0 0.1414213562373095
Fx59_re_a1 0 x59_re_a1 V1 7.0710678118654755
Rp59_re_re_a1 0 x59_re_a1 5.734252219761168e-09
Gp59_re_im_a1 0 x59_re_a1 x59_im_a1 0 201137530.81086907
Cx59_im_a1 x59_im_a1 0 1.0
Gp59_im_re_a1 0 x59_im_a1 x59_re_a1 0 -201137530.81086907
Rp59_im_im_a1 0 x59_im_a1 5.734252219761168e-09
Cx60_re_a1 x60_re_a1 0 1.0
Gx60_re_a1 0 x60_re_a1 p1 0 0.1414213562373095
Fx60_re_a1 0 x60_re_a1 V1 7.0710678118654755
Rp60_re_re_a1 0 x60_re_a1 5.652786094011291e-09
Gp60_re_im_a1 0 x60_re_a1 x60_im_a1 0 618651646.662869
Cx60_im_a1 x60_im_a1 0 1.0
Gp60_im_re_a1 0 x60_im_a1 x60_re_a1 0 -618651646.662869
Rp60_im_im_a1 0 x60_im_a1 5.652786094011291e-09
*
* Port network for port 2
V2 p2 s2 0
R2 s2 0 50.0
Gd2_1 0 s2 p1 0 0.0007408678247312679
Fd2_1 0 s2 V1 0.037043391236563396
Gr1_re_2_1 0 s2 x1_re_a1 0 53156352627.26448
Gr1_im_2_1 0 s2 x1_im_a1 0 -85738328789.12218
Gr2_re_2_1 0 s2 x2_re_a1 0 1.0338152552250434e+16
Gr2_im_2_1 0 s2 x2_im_a1 0 -9193357139184432.0
Gr3_re_2_1 0 s2 x3_re_a1 0 -1.3494674542208832e+17
Gr3_im_2_1 0 s2 x3_im_a1 0 -9.57364210924606e+16
Gr4_re_2_1 0 s2 x4_re_a1 0 2.1223573918213984e+17
Gr4_im_2_1 0 s2 x4_im_a1 0 4.201865202993397e+17
Gr5_re_2_1 0 s2 x5_re_a1 0 2.0777682788783155e+18
Gr5_im_2_1 0 s2 x5_im_a1 0 -4.70238369247884e+17
Gr6_re_2_1 0 s2 x6_re_a1 0 2.8067617876805235e+17
Gr6_im_2_1 0 s2 x6_im_a1 0 2.1235040762940104e+18
Gr7_re_2_1 0 s2 x7_re_a1 0 1.7114667802229453e+18
Gr7_im_2_1 0 s2 x7_im_a1 0 -5.44121693216883e+18
Gr8_re_2_1 0 s2 x8_re_a1 0 4.4525990142853606e+18
Gr8_im_2_1 0 s2 x8_im_a1 0 -4.514823204537731e+18
Gr9_re_2_1 0 s2 x9_re_a1 0 -1.2462076612543685e+19
Gr9_im_2_1 0 s2 x9_im_a1 0 -1.681015107276218e+17
Gr10_re_2_1 0 s2 x10_re_a1 0 -1.5338558634869768e+20
Gr10_im_2_1 0 s2 x10_im_a1 0 -4.378410801573267e+19
Gr11_re_2_1 0 s2 x11_re_a1 0 -4.43797480925111e+19
Gr11_im_2_1 0 s2 x11_im_a1 0 1.0648617059601827e+20
Gr12_re_2_1 0 s2 x12_re_a1 0 4.6251337015228373e+20
Gr12_im_2_1 0 s2 x12_im_a1 0 -2.0475664609451453e+17
Gr13_re_2_1 0 s2 x13_re_a1 0 -1.1904988036435709e+20
Gr13_im_2_1 0 s2 x13_im_a1 0 -8.70552388007159e+19
Gr14_re_2_1 0 s2 x14_re_a1 0 -6.955466610956044e+19
Gr14_im_2_1 0 s2 x14_im_a1 0 1.1399020260506378e+19
Gr15_re_2_1 0 s2 x15_re_a1 0 -9.485866421542242e+19
Gr15_im_2_1 0 s2 x15_im_a1 0 -5.33569270791513e+19
Gr16_re_2_1 0 s2 x16_re_a1 0 -2.6494426765979868e+20
Gr16_im_2_1 0 s2 x16_im_a1 0 -1.2765399380425009e+20
Gr17_re_2_1 0 s2 x17_re_a1 0 1.0450726786502289e+20
Gr17_im_2_1 0 s2 x17_im_a1 0 1.962974437628729e+20
Gr18_re_2_1 0 s2 x18_re_a1 0 -6.355279542838233e+19
Gr18_im_2_1 0 s2 x18_im_a1 0 6.568793340145985e+18
Gr19_re_2_1 0 s2 x19_re_a1 0 2.9505988670474768e+20
Gr19_im_2_1 0 s2 x19_im_a1 0 1.6205935365494558e+20
Gr20_re_2_1 0 s2 x20_re_a1 0 -5.126876512405367e+18
Gr20_im_2_1 0 s2 x20_im_a1 0 -1.5183496482712426e+17
Gr21_re_2_1 0 s2 x21_re_a1 0 2.692567948268134e+20
Gr21_im_2_1 0 s2 x21_im_a1 0 -4.054798952554994e+19
Gr22_re_2_1 0 s2 x22_re_a1 0 -8.51574846507546e+19
Gr22_im_2_1 0 s2 x22_im_a1 0 -5.539911998844891e+19
Gr23_re_2_1 0 s2 x23_re_a1 0 9.935997185775046e+19
Gr23_im_2_1 0 s2 x23_im_a1 0 -1.0282065376901746e+20
Gr24_re_2_1 0 s2 x24_re_a1 0 -1.8306354937047607e+20
Gr24_im_2_1 0 s2 x24_im_a1 0 -6.856551771313197e+18
Gr25_re_2_1 0 s2 x25_re_a1 0 -8.132474339123713e+18
Gr25_im_2_1 0 s2 x25_im_a1 0 -6.629972615705686e+19
Gr26_re_2_1 0 s2 x26_re_a1 0 -2.8878838139716416e+20
Gr26_im_2_1 0 s2 x26_im_a1 0 -1.0510731787149789e+20
Gr27_re_2_1 0 s2 x27_re_a1 0 -2.226617027938643e+19
Gr27_im_2_1 0 s2 x27_im_a1 0 -1.2976892215591395e+19
Gr28_re_2_1 0 s2 x28_re_a1 0 -4.726313048921694e+19
Gr28_im_2_1 0 s2 x28_im_a1 0 6.576531817248688e+19
Gr29_re_2_1 0 s2 x29_re_a1 0 -1.4519927562693258e+20
Gr29_im_2_1 0 s2 x29_im_a1 0 -1.1235326578669904e+20
Gr30_re_2_1 0 s2 x30_re_a1 0 -5.998740657473944e+19
Gr30_im_2_1 0 s2 x30_im_a1 0 3.325389742915566e+20
Gr31_re_2_1 0 s2 x31_re_a1 0 1.478063414993309e+20
Gr31_im_2_1 0 s2 x31_im_a1 0 4.60646251220945e+19
Gr32_re_2_1 0 s2 x32_re_a1 0 6.262326383483841e+19
Gr32_im_2_1 0 s2 x32_im_a1 0 -3.689972574727164e+19
Gr33_re_2_1 0 s2 x33_re_a1 0 1.1646183827207928e+20
Gr33_im_2_1 0 s2 x33_im_a1 0 8.591094415070413e+19
Gr34_re_2_1 0 s2 x34_re_a1 0 1.77799762449243e+20
Gr34_im_2_1 0 s2 x34_im_a1 0 4.5320228012125635e+19
Gr35_re_2_1 0 s2 x35_re_a1 0 7.490960087893652e+19
Gr35_im_2_1 0 s2 x35_im_a1 0 8.989433412889192e+19
Gr36_re_2_1 0 s2 x36_re_a1 0 2.82581835616325e+18
Gr36_im_2_1 0 s2 x36_im_a1 0 -3.802552495568659e+19
Gr37_re_2_1 0 s2 x37_re_a1 0 -4.276027729542332e+20
Gr37_im_2_1 0 s2 x37_im_a1 0 -3.4258708792004385e+20
Gr38_re_2_1 0 s2 x38_re_a1 0 1.4703220523104315e+20
Gr38_im_2_1 0 s2 x38_im_a1 0 7.786691342573322e+19
Gr39_re_2_1 0 s2 x39_re_a1 0 2.418882729992568e+19
Gr39_im_2_1 0 s2 x39_im_a1 0 7.677281400443185e+19
Gr40_re_2_1 0 s2 x40_re_a1 0 1.9528869844265038e+19
Gr40_im_2_1 0 s2 x40_im_a1 0 -1.4885493293517413e+20
Gr41_re_2_1 0 s2 x41_re_a1 0 -6.4971365180521005e+19
Gr41_im_2_1 0 s2 x41_im_a1 0 1.0187445961773706e+20
Gr42_re_2_1 0 s2 x42_re_a1 0 4.268296675499268e+19
Gr42_im_2_1 0 s2 x42_im_a1 0 -4.2577627405258195e+19
Gr43_re_2_1 0 s2 x43_re_a1 0 -1.2052115386711446e+20
Gr43_im_2_1 0 s2 x43_im_a1 0 -1.000426524719638e+19
Gr44_re_2_1 0 s2 x44_re_a1 0 -6.004277989563153e+19
Gr44_im_2_1 0 s2 x44_im_a1 0 6.9817728274319745e+19
Gr45_re_2_1 0 s2 x45_re_a1 0 -1.1720244336823142e+20
Gr45_im_2_1 0 s2 x45_im_a1 0 5.850446800945927e+18
Gr46_re_2_1 0 s2 x46_re_a1 0 1.2068611218835137e+20
Gr46_im_2_1 0 s2 x46_im_a1 0 7.896250092916579e+19
Gr47_re_2_1 0 s2 x47_re_a1 0 -9.742529505716172e+19
Gr47_im_2_1 0 s2 x47_im_a1 0 5.235067523681644e+19
Gr48_re_2_1 0 s2 x48_re_a1 0 -5.751282276123425e+19
Gr48_im_2_1 0 s2 x48_im_a1 0 6.328948479282769e+18
Gr49_re_2_1 0 s2 x49_re_a1 0 -3.4261917385797915e+19
Gr49_im_2_1 0 s2 x49_im_a1 0 -1.3126078140095185e+19
Gr50_re_2_1 0 s2 x50_re_a1 0 1.6409104289234151e+19
Gr50_im_2_1 0 s2 x50_im_a1 0 -9.684837937965486e+18
Gr51_re_2_1 0 s2 x51_re_a1 0 4.862987468404429e+19
Gr51_im_2_1 0 s2 x51_im_a1 0 -4.802197548189514e+18
Gr52_re_2_1 0 s2 x52_re_a1 0 5.429806624704677e+19
Gr52_im_2_1 0 s2 x52_im_a1 0 -3.769811293214425e+18
Gr53_re_2_1 0 s2 x53_re_a1 0 6.569116967014904e+19
Gr53_im_2_1 0 s2 x53_im_a1 0 -1.9479114785610657e+18
Gr54_re_2_1 0 s2 x54_re_a1 0 7.009070821411367e+19
Gr54_im_2_1 0 s2 x54_im_a1 0 -1.360426089684427e+18
Gr55_re_2_1 0 s2 x55_re_a1 0 7.220469868277652e+19
Gr55_im_2_1 0 s2 x55_im_a1 0 -8.431115606116637e+17
Gr56_re_2_1 0 s2 x56_re_a1 0 6.746792573844537e+19
Gr56_im_2_1 0 s2 x56_im_a1 0 -4.6625121119417043e+17
Gr57_re_2_1 0 s2 x57_re_a1 0 2.202471808200646e+19
Gr57_im_2_1 0 s2 x57_im_a1 0 -8.025610380019536e+16
Gr58_re_2_1 0 s2 x58_re_a1 0 5.021478440974402e+19
Gr58_im_2_1 0 s2 x58_im_a1 0 -2.193305593256358e+17
Gr59_re_2_1 0 s2 x59_re_a1 0 1.1719661053551554e+17
Gr59_im_2_1 0 s2 x59_im_a1 0 -1684227518465977.2
Gr60_re_2_1 0 s2 x60_re_a1 0 3.7117028336294733e+18
Gr60_im_2_1 0 s2 x60_im_a1 0 -1.854964433740738e+16
Gd2_2 0 s2 p2 0 -0.0011693176671043132
Fd2_2 0 s2 V2 -0.058465883355215666
Gr1_re_2_2 0 s2 x1_re_a2 0 -6236468011.767205
Gr1_im_2_2 0 s2 x1_im_a2 0 -18416004079.700817
Gr2_re_2_2 0 s2 x2_re_a2 0 290899829136537.2
Gr2_im_2_2 0 s2 x2_im_a2 0 -2254051782239204.5
Gr3_re_2_2 0 s2 x3_re_a2 0 -2.6836974520708756e+16
Gr3_im_2_2 0 s2 x3_im_a2 0 2230048841676243.0
Gr4_re_2_2 0 s2 x4_re_a2 0 6.921618681995995e+16
Gr4_im_2_2 0 s2 x4_im_a2 0 3.0890563849943816e+16
Gr5_re_2_2 0 s2 x5_re_a2 0 2.5287283570290128e+17
Gr5_im_2_2 0 s2 x5_im_a2 0 -2.5726791021539334e+17
Gr6_re_2_2 0 s2 x6_re_a2 0 2.3269017339797002e+17
Gr6_im_2_2 0 s2 x6_im_a2 0 2.4048239289321635e+17
Gr7_re_2_2 0 s2 x7_re_a2 0 -2.7396379026939766e+17
Gr7_im_2_2 0 s2 x7_im_a2 0 -8.400696796700806e+17
Gr8_re_2_2 0 s2 x8_re_a2 0 1.9926808244158886e+17
Gr8_im_2_2 0 s2 x8_im_a2 0 -9.32881303295873e+17
Gr9_re_2_2 0 s2 x9_re_a2 0 -1.606763901859787e+18
Gr9_im_2_2 0 s2 x9_im_a2 0 9.002121419908404e+17
Gr10_re_2_2 0 s2 x10_re_a2 0 -2.2516605048545817e+19
Gr10_im_2_2 0 s2 x10_im_a2 0 3.6654772451517844e+18
Gr11_re_2_2 0 s2 x11_re_a2 0 2.4826576364204688e+17
Gr11_im_2_2 0 s2 x11_im_a2 0 1.6314355429236814e+19
Gr12_re_2_2 0 s2 x12_re_a2 0 6.096270758109425e+19
Gr12_im_2_2 0 s2 x12_im_a2 0 -2.275208219118278e+19
Gr13_re_2_2 0 s2 x13_re_a2 0 -1.857777634507814e+19
Gr13_im_2_2 0 s2 x13_im_a2 0 -7.520570527409904e+18
Gr14_re_2_2 0 s2 x14_re_a2 0 -9.28420570593671e+18
Gr14_im_2_2 0 s2 x14_im_a2 0 -5.484285754185938e+18
Gr15_re_2_2 0 s2 x15_re_a2 0 -1.677744842047821e+19
Gr15_im_2_2 0 s2 x15_im_a2 0 4.762924681624151e+18
Gr16_re_2_2 0 s2 x16_re_a2 0 -3.980922815380895e+19
Gr16_im_2_2 0 s2 x16_im_a2 0 -4.644942265798354e+18
Gr17_re_2_2 0 s2 x17_re_a2 0 1.774018921177543e+19
Gr17_im_2_2 0 s2 x17_im_a2 0 2.5070022246578676e+19
Gr18_re_2_2 0 s2 x18_re_a2 0 -6.065490607509927e+18
Gr18_im_2_2 0 s2 x18_im_a2 0 7.610673911506133e+18
Gr19_re_2_2 0 s2 x19_re_a2 0 4.491120092406446e+19
Gr19_im_2_2 0 s2 x19_im_a2 0 1.2305037554293422e+19
Gr20_re_2_2 0 s2 x20_re_a2 0 3.691322969467451e+18
Gr20_im_2_2 0 s2 x20_im_a2 0 -1.1510773639041037e+18
Gr21_re_2_2 0 s2 x21_re_a2 0 3.3954930593251725e+19
Gr21_im_2_2 0 s2 x21_im_a2 0 -1.518535843224394e+19
Gr22_re_2_2 0 s2 x22_re_a2 0 -8.652943444356569e+18
Gr22_im_2_2 0 s2 x22_im_a2 0 -1.0663877721248674e+19
Gr23_re_2_2 0 s2 x23_re_a2 0 7.98745862091545e+18
Gr23_im_2_2 0 s2 x23_im_a2 0 -1.9043807498708533e+19
Gr24_re_2_2 0 s2 x24_re_a2 0 -2.3048657379887903e+19
Gr24_im_2_2 0 s2 x24_im_a2 0 -3.682800549722348e+18
Gr25_re_2_2 0 s2 x25_re_a2 0 -7.822750183150739e+18
Gr25_im_2_2 0 s2 x25_im_a2 0 -7.475370628187586e+18
Gr26_re_2_2 0 s2 x26_re_a2 0 -4.002147315669878e+19
Gr26_im_2_2 0 s2 x26_im_a2 0 -6.792800869510219e+18
Gr27_re_2_2 0 s2 x27_re_a2 0 -6.811656085631157e+18
Gr27_im_2_2 0 s2 x27_im_a2 0 1.35168138998535e+18
Gr28_re_2_2 0 s2 x28_re_a2 0 -5.615360629700193e+18
Gr28_im_2_2 0 s2 x28_im_a2 0 8.691787625299556e+18
Gr29_re_2_2 0 s2 x29_re_a2 0 -2.3361226911258325e+19
Gr29_im_2_2 0 s2 x29_im_a2 0 -6.138459387122623e+18
Gr30_re_2_2 0 s2 x30_re_a2 0 2.1063489439616453e+18
Gr30_im_2_2 0 s2 x30_im_a2 0 5.409516239112451e+19
Gr31_re_2_2 0 s2 x31_re_a2 0 1.7754031517991651e+19
Gr31_im_2_2 0 s2 x31_im_a2 0 2.028617523918061e+18
Gr32_re_2_2 0 s2 x32_re_a2 0 6.801712795565208e+18
Gr32_im_2_2 0 s2 x32_im_a2 0 2.8299875710880456e+18
Gr33_re_2_2 0 s2 x33_re_a2 0 1.9178763195586904e+19
Gr33_im_2_2 0 s2 x33_im_a2 0 4.627804992894501e+18
Gr34_re_2_2 0 s2 x34_re_a2 0 2.1718593780428513e+19
Gr34_im_2_2 0 s2 x34_im_a2 0 9.51336018636963e+18
Gr35_re_2_2 0 s2 x35_re_a2 0 1.4502666720018967e+19
Gr35_im_2_2 0 s2 x35_im_a2 0 7.172566622700204e+18
Gr36_re_2_2 0 s2 x36_re_a2 0 3.2333793190211533e+18
Gr36_im_2_2 0 s2 x36_im_a2 0 -4.666593016890486e+18
Gr37_re_2_2 0 s2 x37_re_a2 0 -6.980271078536075e+19
Gr37_im_2_2 0 s2 x37_im_a2 0 -6.050993378419765e+19
Gr38_re_2_2 0 s2 x38_re_a2 0 1.994575352642411e+19
Gr38_im_2_2 0 s2 x38_im_a2 0 7.25204758567168e+18
Gr39_re_2_2 0 s2 x39_re_a2 0 9.325406342541736e+18
Gr39_im_2_2 0 s2 x39_im_a2 0 5.30355981285829e+18
Gr40_re_2_2 0 s2 x40_re_a2 0 4.626665056655541e+17
Gr40_im_2_2 0 s2 x40_im_a2 0 -1.9094284128790467e+19
Gr41_re_2_2 0 s2 x41_re_a2 0 -1.6965790009045551e+19
Gr41_im_2_2 0 s2 x41_im_a2 0 3.61665052698603e+18
Gr42_re_2_2 0 s2 x42_re_a2 0 9.460905455088589e+18
Gr42_im_2_2 0 s2 x42_im_a2 0 6.39511186414937e+18
Gr43_re_2_2 0 s2 x43_re_a2 0 -1.5655349805526503e+19
Gr43_im_2_2 0 s2 x43_im_a2 0 5.854596386552805e+18
Gr44_re_2_2 0 s2 x44_re_a2 0 -8.107449059828092e+18
Gr44_im_2_2 0 s2 x44_im_a2 0 9.086961076473857e+18
Gr45_re_2_2 0 s2 x45_re_a2 0 -1.2777544038328285e+19
Gr45_im_2_2 0 s2 x45_im_a2 0 1.0115075912660038e+19
Gr46_re_2_2 0 s2 x46_re_a2 0 1.5694883721780687e+19
Gr46_im_2_2 0 s2 x46_im_a2 0 1.3845806571478307e+19
Gr47_re_2_2 0 s2 x47_re_a2 0 -1.0308055981295559e+19
Gr47_im_2_2 0 s2 x47_im_a2 0 1.1222815138211494e+19
Gr48_re_2_2 0 s2 x48_re_a2 0 -4.906057936091116e+18
Gr48_im_2_2 0 s2 x48_im_a2 0 5.781020735035727e+18
Gr49_re_2_2 0 s2 x49_re_a2 0 -2.7903744069840307e+18
Gr49_im_2_2 0 s2 x49_im_a2 0 2.0285689276796506e+18
Gr50_re_2_2 0 s2 x50_re_a2 0 2.786227582105883e+18
Gr50_im_2_2 0 s2 x50_im_a2 0 5.114060449690233e+17
Gr51_re_2_2 0 s2 x51_re_a2 0 6.4638695820988e+18
Gr51_im_2_2 0 s2 x51_im_a2 0 1.9793229942227168e+17
Gr52_re_2_2 0 s2 x52_re_a2 0 7.18251990136051e+18
Gr52_im_2_2 0 s2 x52_im_a2 0 1.6984773885140877e+17
Gr53_re_2_2 0 s2 x53_re_a2 0 8.529779158398908e+18
Gr53_im_2_2 0 s2 x53_im_a2 0 9.243607597298456e+16
Gr54_re_2_2 0 s2 x54_re_a2 0 8.988534409767152e+18
Gr54_im_2_2 0 s2 x54_im_a2 0 6.001079827544015e+16
Gr55_re_2_2 0 s2 x55_re_a2 0 9.163548963410645e+18
Gr55_im_2_2 0 s2 x55_im_a2 0 3.456775215832789e+16
Gr56_re_2_2 0 s2 x56_re_a2 0 8.502080952743773e+18
Gr56_im_2_2 0 s2 x56_im_a2 0 1.826384846614749e+16
Gr57_re_2_2 0 s2 x57_re_a2 0 2.7554348435877944e+18
Gr57_im_2_2 0 s2 x57_im_a2 0 3019578275849538.5
Gr58_re_2_2 0 s2 x58_re_a2 0 6.299906112297473e+18
Gr58_im_2_2 0 s2 x58_im_a2 0 8333327991196468.0
Gr59_re_2_2 0 s2 x59_re_a2 0 1.462356784290343e+16
Gr59_im_2_2 0 s2 x59_im_a2 0 61092423320581.08
Gr60_re_2_2 0 s2 x60_re_a2 0 4.636680811029802e+17
Gr60_im_2_2 0 s2 x60_im_a2 0 694258116174289.4
Gd2_3 0 s2 p3 0 1.2155334855554352e-06
Fd2_3 0 s2 V3 6.0776674277771756e-05
Gr1_re_2_3 0 s2 x1_re_a3 0 17648806023.37745
Gr1_im_2_3 0 s2 x1_im_a3 0 -26012846335.044296
Gr2_re_2_3 0 s2 x2_re_a3 0 3319874738800377.5
Gr2_im_2_3 0 s2 x2_im_a3 0 -2763618099317637.0
Gr3_re_2_3 0 s2 x3_re_a3 0 -4.11565692274056e+16
Gr3_im_2_3 0 s2 x3_im_a3 0 -3.121334709407087e+16
Gr4_re_2_3 0 s2 x4_re_a3 0 6.216187937395932e+16
Gr4_im_2_3 0 s2 x4_im_a3 0 1.331504166805438e+17
Gr5_re_2_3 0 s2 x5_re_a3 0 6.491568277421727e+17
Gr5_im_2_3 0 s2 x5_im_a3 0 -1.2782412280834658e+17
Gr6_re_2_3 0 s2 x6_re_a3 0 6.8693371680665064e+16
Gr6_im_2_3 0 s2 x6_im_a3 0 6.649645835638748e+17
Gr7_re_2_3 0 s2 x7_re_a3 0 5.807442956330368e+17
Gr7_im_2_3 0 s2 x7_im_a3 0 -1.682530775861952e+18
Gr8_re_2_3 0 s2 x8_re_a3 0 1.4238773579016067e+18
Gr8_im_2_3 0 s2 x8_im_a3 0 -1.3734370482278879e+18
Gr9_re_2_3 0 s2 x9_re_a3 0 -3.8845069430296325e+18
Gr9_im_2_3 0 s2 x9_im_a3 0 -1.414240839413402e+17
Gr10_re_2_3 0 s2 x10_re_a3 0 -4.7550728179076415e+19
Gr10_im_2_3 0 s2 x10_im_a3 0 -1.4553465339904287e+19
Gr11_re_2_3 0 s2 x11_re_a3 0 -1.441626748233537e+19
Gr11_im_2_3 0 s2 x11_im_a3 0 3.2945986111854637e+19
Gr12_re_2_3 0 s2 x12_re_a3 0 1.440695572645924e+20
Gr12_im_2_3 0 s2 x12_im_a3 0 2.1511662283717015e+18
Gr13_re_2_3 0 s2 x13_re_a3 0 -3.680334258286781e+19
Gr13_im_2_3 0 s2 x13_im_a3 0 -2.7507857441921204e+19
Gr14_re_2_3 0 s2 x14_re_a3 0 -2.1672677844509905e+19
Gr14_im_2_3 0 s2 x14_im_a3 0 4.2227460492739584e+18
Gr15_re_2_3 0 s2 x15_re_a3 0 -2.9120892760077693e+19
Gr15_im_2_3 0 s2 x15_im_a3 0 -1.776360534162485e+19
Gr16_re_2_3 0 s2 x16_re_a3 0 -8.20528766770644e+19
Gr16_im_2_3 0 s2 x16_im_a3 0 -4.096077782673208e+19
Gr17_re_2_3 0 s2 x17_re_a3 0 3.2167207441172767e+19
Gr17_im_2_3 0 s2 x17_im_a3 0 6.123979375802051e+19
Gr18_re_2_3 0 s2 x18_re_a3 0 -2.0016835506934886e+19
Gr18_im_2_3 0 s2 x18_im_a3 0 1.3854883932939415e+18
Gr19_re_2_3 0 s2 x19_re_a3 0 9.133034742927671e+19
Gr19_im_2_3 0 s2 x19_im_a3 0 5.137986588221861e+19
Gr20_re_2_3 0 s2 x20_re_a3 0 -2.0237575588278305e+18
Gr20_im_2_3 0 s2 x20_im_a3 0 5.665783820565369e+16
Gr21_re_2_3 0 s2 x21_re_a3 0 8.4034101773186e+19
Gr21_im_2_3 0 s2 x21_im_a3 0 -1.1662676627127263e+19
Gr22_re_2_3 0 s2 x22_re_a3 0 -2.6786317690218746e+19
Gr22_im_2_3 0 s2 x22_im_a3 0 -1.694058059439334e+19
Gr23_re_2_3 0 s2 x23_re_a3 0 3.14543669756796e+19
Gr23_im_2_3 0 s2 x23_im_a3 0 -3.1491596102443336e+19
Gr24_re_2_3 0 s2 x24_re_a3 0 -5.714808375113766e+19
Gr24_im_2_3 0 s2 x24_im_a3 0 -1.873422070363325e+18
Gr25_re_2_3 0 s2 x25_re_a3 0 -1.8709660029033078e+18
Gr25_im_2_3 0 s2 x25_im_a3 0 -2.0773947141858845e+19
Gr26_re_2_3 0 s2 x26_re_a3 0 -8.977971854034064e+19
Gr26_im_2_3 0 s2 x26_im_a3 0 -3.3447441894494876e+19
Gr27_re_2_3 0 s2 x27_re_a3 0 -6.55504012701875e+18
Gr27_im_2_3 0 s2 x27_im_a3 0 -4.339559516119073e+18
Gr28_re_2_3 0 s2 x28_re_a3 0 -1.4788611780322097e+19
Gr28_im_2_3 0 s2 x28_im_a3 0 2.048707526966895e+19
Gr29_re_2_3 0 s2 x29_re_a3 0 -4.481689565725411e+19
Gr29_im_2_3 0 s2 x29_im_a3 0 -3.5856360223345324e+19
Gr30_re_2_3 0 s2 x30_re_a3 0 -1.9671407766245278e+19
Gr30_im_2_3 0 s2 x30_im_a3 0 1.0259854281717295e+20
Gr31_re_2_3 0 s2 x31_re_a3 0 4.6218420616436425e+19
Gr31_im_2_3 0 s2 x31_im_a3 0 1.4754766920247923e+19
Gr32_re_2_3 0 s2 x32_re_a3 0 1.9662442744715284e+19
Gr32_im_2_3 0 s2 x32_im_a3 0 -1.2248510894508691e+19
Gr33_re_2_3 0 s2 x33_re_a3 0 3.590490842678532e+19
Gr33_im_2_3 0 s2 x33_im_a3 0 2.7424757313848955e+19
Gr34_re_2_3 0 s2 x34_re_a3 0 5.556993750946768e+19
Gr34_im_2_3 0 s2 x34_im_a3 0 1.3779245217841476e+19
Gr35_re_2_3 0 s2 x35_re_a3 0 2.2881325907298497e+19
Gr35_im_2_3 0 s2 x35_im_a3 0 2.8466918217277465e+19
Gr36_re_2_3 0 s2 x36_re_a3 0 6.007878975046484e+17
Gr36_im_2_3 0 s2 x36_im_a3 0 -1.188397261123492e+19
Gr37_re_2_3 0 s2 x37_re_a3 0 -1.3191688615456655e+20
Gr37_im_2_3 0 s2 x37_im_a3 0 -1.052380981970615e+20
Gr38_re_2_3 0 s2 x38_re_a3 0 4.575435800455305e+19
Gr38_im_2_3 0 s2 x38_im_a3 0 2.4560352353322893e+19
Gr39_re_2_3 0 s2 x39_re_a3 0 6.929887812389471e+18
Gr39_im_2_3 0 s2 x39_im_a3 0 2.4390757905227887e+19
Gr40_re_2_3 0 s2 x40_re_a3 0 6.295174139897056e+18
Gr40_im_2_3 0 s2 x40_im_a3 0 -4.64312739195909e+19
Gr41_re_2_3 0 s2 x41_re_a3 0 -1.9423586939849683e+19
Gr41_im_2_3 0 s2 x41_im_a3 0 3.27099608892508e+19
Gr42_re_2_3 0 s2 x42_re_a3 0 1.2927520028511525e+19
Gr42_im_2_3 0 s2 x42_im_a3 0 -1.4448123037435097e+19
Gr43_re_2_3 0 s2 x43_re_a3 0 -3.7573393196842344e+19
Gr43_im_2_3 0 s2 x43_im_a3 0 -3.82362275840516e+18
Gr44_re_2_3 0 s2 x44_re_a3 0 -1.8689867448299504e+19
Gr44_im_2_3 0 s2 x44_im_a3 0 2.1765265988647367e+19
Gr45_re_2_3 0 s2 x45_re_a3 0 -3.6779849016272904e+19
Gr45_im_2_3 0 s2 x45_im_a3 0 9.026788691296102e+17
Gr46_re_2_3 0 s2 x46_re_a3 0 3.762526228763959e+19
Gr46_im_2_3 0 s2 x46_im_a3 0 2.4265869096099017e+19
Gr47_re_2_3 0 s2 x47_re_a3 0 -3.0605508419152028e+19
Gr47_im_2_3 0 s2 x47_im_a3 0 1.5885892465607094e+19
Gr48_re_2_3 0 s2 x48_re_a3 0 -1.818305065592989e+19
Gr48_im_2_3 0 s2 x48_im_a3 0 1.485112231055098e+18
Gr49_re_2_3 0 s2 x49_re_a3 0 -1.0844963203587365e+19
Gr49_im_2_3 0 s2 x49_im_a3 0 -4.4597719099200604e+18
Gr50_re_2_3 0 s2 x50_re_a3 0 5.051751157387e+18
Gr50_im_2_3 0 s2 x50_im_a3 0 -3.193562485371419e+18
Gr51_re_2_3 0 s2 x51_re_a3 0 1.5147193409613388e+19
Gr51_im_2_3 0 s2 x51_im_a3 0 -1.5780375526863452e+18
Gr52_re_2_3 0 s2 x52_re_a3 0 1.6916100474719447e+19
Gr52_im_2_3 0 s2 x52_im_a3 0 -1.2402103282444756e+18
Gr53_re_2_3 0 s2 x53_re_a3 0 2.048116558936913e+19
Gr53_im_2_3 0 s2 x53_im_a3 0 -6.412923337777339e+17
Gr54_re_2_3 0 s2 x54_re_a3 0 2.1863894841530487e+19
Gr54_im_2_3 0 s2 x54_im_a3 0 -4.474325022487589e+17
Gr55_re_2_3 0 s2 x55_re_a3 0 2.2532757212902597e+19
Gr55_im_2_3 0 s2 x55_im_a3 0 -2.7703387931342483e+17
Gr56_re_2_3 0 s2 x56_re_a3 0 2.1060479155022004e+19
Gr56_im_2_3 0 s2 x56_im_a3 0 -1.53119230248033e+17
Gr57_re_2_3 0 s2 x57_re_a3 0 6.877100807970906e+18
Gr57_im_2_3 0 s2 x57_im_a3 0 -2.6344276401877316e+16
Gr58_re_2_3 0 s2 x58_re_a3 0 1.567756129001729e+19
Gr58_im_2_3 0 s2 x58_im_a3 0 -7.200382186001196e+16
Gr59_re_2_3 0 s2 x59_re_a3 0 3.659778863180994e+16
Gr59_im_2_3 0 s2 x59_im_a3 0 -552627648712426.25
Gr60_re_2_3 0 s2 x60_re_a3 0 1.1590269651007567e+18
Gr60_im_2_3 0 s2 x60_im_a3 0 -6088608246281059.0
Gd2_4 0 s2 p4 0 0.0002049335955199544
Fd2_4 0 s2 V4 0.01024667977599772
Gr1_re_2_4 0 s2 x1_re_a4 0 -7359585466.235559
Gr1_im_2_4 0 s2 x1_im_a4 0 13123160200.064117
Gr2_re_2_4 0 s2 x2_re_a4 0 -1497957158489212.5
Gr2_im_2_4 0 s2 x2_im_a4 0 1426998585404242.0
Gr3_re_2_4 0 s2 x3_re_a4 0 2.0649052928996624e+16
Gr3_im_2_4 0 s2 x3_im_a4 0 1.3638917699057064e+16
Gr4_re_2_4 0 s2 x4_re_a4 0 -3.3756173045503924e+16
Gr4_im_2_4 0 s2 x4_im_a4 0 -6.179643690099422e+16
Gr5_re_2_4 0 s2 x5_re_a4 0 -3.104046947930305e+17
Gr5_im_2_4 0 s2 x5_im_a4 0 7.971069693247973e+16
Gr6_re_2_4 0 s2 x6_re_a4 0 -5.1303088228075576e+16
Gr6_im_2_4 0 s2 x6_im_a4 0 -3.1632716505087334e+17
Gr7_re_2_4 0 s2 x7_re_a4 0 -2.3287926835610954e+17
Gr7_im_2_4 0 s2 x7_im_a4 0 8.211376662077229e+17
Gr8_re_2_4 0 s2 x8_re_a4 0 -6.490051232105906e+17
Gr8_im_2_4 0 s2 x8_im_a4 0 6.924489590321129e+17
Gr9_re_2_4 0 s2 x9_re_a4 0 1.865888028849871e+18
Gr9_im_2_4 0 s2 x9_im_a4 0 -1.80983078047587e+16
Gr10_re_2_4 0 s2 x10_re_a4 0 2.3095662377764487e+19
Gr10_im_2_4 0 s2 x10_im_a4 0 6.120670620953752e+18
Gr11_re_2_4 0 s2 x11_re_a4 0 6.366549586081064e+18
Gr11_im_2_4 0 s2 x11_im_a4 0 -1.6066050107391988e+19
Gr12_re_2_4 0 s2 x12_re_a4 0 -6.932198402926829e+19
Gr12_im_2_4 0 s2 x12_im_a4 0 1.0909226116146508e+18
Gr13_re_2_4 0 s2 x13_re_a4 0 1.7978476074421539e+19
Gr13_im_2_4 0 s2 x13_im_a4 0 1.2865178612863957e+19
Gr14_re_2_4 0 s2 x14_re_a4 0 1.0436275270266501e+19
Gr14_im_2_4 0 s2 x14_im_a4 0 -1.3797573267078702e+18
Gr15_re_2_4 0 s2 x15_re_a4 0 1.4413589150383917e+19
Gr15_im_2_4 0 s2 x15_im_a4 0 7.444842750470997e+18
Gr16_re_2_4 0 s2 x16_re_a4 0 3.993853933176836e+19
Gr16_im_2_4 0 s2 x16_im_a4 0 1.8567867696716554e+19
Gr17_re_2_4 0 s2 x17_re_a4 0 -1.5848906118140772e+19
Gr17_im_2_4 0 s2 x17_im_a4 0 -2.9388996126986424e+19
Gr18_re_2_4 0 s2 x18_re_a4 0 9.416020667034526e+18
Gr18_im_2_4 0 s2 x18_im_a4 0 -1.2981709736104202e+18
Gr19_re_2_4 0 s2 x19_re_a4 0 -4.450745313961389e+19
Gr19_im_2_4 0 s2 x19_im_a4 0 -2.387249140877465e+19
Gr20_re_2_4 0 s2 x20_re_a4 0 5.650521002073562e+17
Gr20_im_2_4 0 s2 x20_im_a4 0 7.75627519279774e+16
Gr21_re_2_4 0 s2 x21_re_a4 0 -4.028904816061557e+19
Gr21_im_2_4 0 s2 x21_im_a4 0 6.533851033719932e+18
Gr22_re_2_4 0 s2 x22_re_a4 0 1.2646716457694937e+19
Gr22_im_2_4 0 s2 x22_im_a4 0 8.463917032414765e+18
Gr23_re_2_4 0 s2 x23_re_a4 0 -1.4655874994022486e+19
Gr23_im_2_4 0 s2 x23_im_a4 0 1.5666767746025587e+19
Gr24_re_2_4 0 s2 x24_re_a4 0 2.739377483373476e+19
Gr24_im_2_4 0 s2 x24_im_a4 0 1.160003279014161e+18
Gr25_re_2_4 0 s2 x25_re_a4 0 1.5325296262655867e+18
Gr25_im_2_4 0 s2 x25_im_a4 0 9.877769391974136e+18
Gr26_re_2_4 0 s2 x26_re_a4 0 4.338011988643448e+19
Gr26_im_2_4 0 s2 x26_im_a4 0 1.5430184099219304e+19
Gr27_re_2_4 0 s2 x27_re_a4 0 3.5172467575932385e+18
Gr27_im_2_4 0 s2 x27_im_a4 0 1.8017452521235574e+18
Gr28_re_2_4 0 s2 x28_re_a4 0 7.057305258862847e+18
Gr28_im_2_4 0 s2 x28_im_a4 0 -9.859365223005485e+18
Gr29_re_2_4 0 s2 x29_re_a4 0 2.195969163407048e+19
Gr29_im_2_4 0 s2 x29_im_a4 0 1.6439550637423649e+19
Gr30_re_2_4 0 s2 x30_re_a4 0 8.526808627792906e+18
Gr30_im_2_4 0 s2 x30_im_a4 0 -5.032525655138454e+19
Gr31_re_2_4 0 s2 x31_re_a4 0 -2.207580829654032e+19
Gr31_im_2_4 0 s2 x31_im_a4 0 -6.719367552386203e+18
Gr32_re_2_4 0 s2 x32_re_a4 0 -9.322849761760102e+18
Gr32_im_2_4 0 s2 x32_im_a4 0 5.173092417368509e+18
Gr33_re_2_4 0 s2 x33_re_a4 0 -1.7634413502266722e+19
Gr33_im_2_4 0 s2 x33_im_a4 0 -1.25676623323575e+19
Gr34_re_2_4 0 s2 x34_re_a4 0 -2.6574968607685943e+19
Gr34_im_2_4 0 s2 x34_im_a4 0 -6.960148723359716e+18
Gr35_re_2_4 0 s2 x35_re_a4 0 -1.144314128904398e+19
Gr35_im_2_4 0 s2 x35_im_a4 0 -1.3258375926509928e+19
Gr36_re_2_4 0 s2 x36_re_a4 0 -5.568368851736846e+17
Gr36_im_2_4 0 s2 x36_im_a4 0 5.685011011809553e+18
Gr37_re_2_4 0 s2 x37_re_a4 0 6.472722196802633e+19
Gr37_im_2_4 0 s2 x37_im_a4 0 5.207063531863557e+19
Gr38_re_2_4 0 s2 x38_re_a4 0 -2.206701657345206e+19
Gr38_im_2_4 0 s2 x38_im_a4 0 -1.15340564787991e+19
Gr39_re_2_4 0 s2 x39_re_a4 0 -3.909714657110795e+18
Gr39_im_2_4 0 s2 x39_im_a4 0 -1.128440122348815e+19
Gr40_re_2_4 0 s2 x40_re_a4 0 -2.830483141636001e+18
Gr40_im_2_4 0 s2 x40_im_a4 0 2.2290138113512583e+19
Gr41_re_2_4 0 s2 x41_re_a4 0 1.0131478882476956e+19
Gr41_im_2_4 0 s2 x41_im_a4 0 -1.4817864032309168e+19
Gr42_re_2_4 0 s2 x42_re_a4 0 -6.578224938999026e+18
Gr42_im_2_4 0 s2 x42_im_a4 0 5.826177786542331e+18
Gr43_re_2_4 0 s2 x43_re_a4 0 1.8056170477106444e+19
Gr43_im_2_4 0 s2 x43_im_a4 0 1.1673467425705165e+18
Gr44_re_2_4 0 s2 x44_re_a4 0 9.010181283410603e+18
Gr44_im_2_4 0 s2 x44_im_a4 0 -1.046100587182722e+19
Gr45_re_2_4 0 s2 x45_re_a4 0 1.7445633156429783e+19
Gr45_im_2_4 0 s2 x45_im_a4 0 -1.3100302447128573e+18
Gr46_re_2_4 0 s2 x46_re_a4 0 -1.8082445008356667e+19
Gr46_im_2_4 0 s2 x46_im_a4 0 -1.1996945069480958e+19
Gr47_re_2_4 0 s2 x47_re_a4 0 1.448764934002234e+19
Gr47_im_2_4 0 s2 x47_im_a4 0 -8.048216558692383e+18
Gr48_re_2_4 0 s2 x48_re_a4 0 8.497711432919563e+18
Gr48_im_2_4 0 s2 x48_im_a4 0 -1.1780988772984317e+18
Gr49_re_2_4 0 s2 x49_re_a4 0 5.056120697737885e+18
Gr49_im_2_4 0 s2 x49_im_a4 0 1.7934796520382351e+18
Gr50_re_2_4 0 s2 x50_re_a4 0 -2.488891987573792e+18
Gr50_im_2_4 0 s2 x50_im_a4 0 1.3689583648240384e+18
Gr51_re_2_4 0 s2 x51_re_a4 0 -7.292715508961488e+18
Gr51_im_2_4 0 s2 x51_im_a4 0 6.813723315031772e+17
Gr52_re_2_4 0 s2 x52_re_a4 0 -8.141114596222623e+18
Gr52_im_2_4 0 s2 x52_im_a4 0 5.3421839467322394e+17
Gr53_re_2_4 0 s2 x53_re_a4 0 -9.8418884970762e+18
Gr53_im_2_4 0 s2 x53_im_a4 0 2.75820834293195e+17
Gr54_re_2_4 0 s2 x54_re_a4 0 -1.0495804297304345e+19
Gr54_im_2_4 0 s2 x54_im_a4 0 1.9284468299960125e+17
Gr55_re_2_4 0 s2 x55_re_a4 0 -1.0807902923006796e+19
Gr55_im_2_4 0 s2 x55_im_a4 0 1.196353026661364e+17
Gr56_re_2_4 0 s2 x56_re_a4 0 -1.0096079747710964e+19
Gr56_im_2_4 0 s2 x56_im_a4 0 6.619932122295458e+16
Gr57_re_2_4 0 s2 x57_re_a4 0 -3.2949056698014986e+18
Gr57_im_2_4 0 s2 x57_im_a4 0 1.1400684338897974e+16
Gr58_re_2_4 0 s2 x58_re_a4 0 -7.512972548564279e+18
Gr58_im_2_4 0 s2 x58_im_a4 0 3.115297648912752e+16
Gr59_re_2_4 0 s2 x59_re_a4 0 -1.7530865447553432e+16
Gr59_im_2_4 0 s2 x59_im_a4 0 239356204480460.7
Gr60_re_2_4 0 s2 x60_re_a4 0 -5.552399619314246e+17
Gr60_im_2_4 0 s2 x60_im_a4 0 2635216669982450.5
*
* State networks driven by port 2
Cx1_re_a2 x1_re_a2 0 1.0
Gx1_re_a2 0 x1_re_a2 p2 0 0.1414213562373095
Fx1_re_a2 0 x1_re_a2 V2 7.0710678118654755
Rp1_re_re_a2 0 x1_re_a2 1.9339271087549648e-10
Gp1_re_im_a2 0 x1_re_a2 x1_im_a2 0 347079283315.0595
Cx1_im_a2 x1_im_a2 0 1.0
Gp1_im_re_a2 0 x1_im_a2 x1_re_a2 0 -347079283315.0595
Rp1_im_im_a2 0 x1_im_a2 1.9339271087549648e-10
Cx2_re_a2 x2_re_a2 0 1.0
Gx2_re_a2 0 x2_re_a2 p2 0 0.1414213562373095
Fx2_re_a2 0 x2_re_a2 V2 7.0710678118654755
Rp2_re_re_a2 0 x2_re_a2 5.691004706881973e-10
Gp2_re_im_a2 0 x2_re_a2 x2_im_a2 0 303418375537.5658
Cx2_im_a2 x2_im_a2 0 1.0
Gp2_im_re_a2 0 x2_im_a2 x2_re_a2 0 -303418375537.5658
Rp2_im_im_a2 0 x2_im_a2 5.691004706881973e-10
Cx3_re_a2 x3_re_a2 0 1.0
Gx3_re_a2 0 x3_re_a2 p2 0 0.1414213562373095
Fx3_re_a2 0 x3_re_a2 V2 7.0710678118654755
Rp3_re_re_a2 0 x3_re_a2 5.362465275255059e-10
Gp3_re_im_a2 0 x3_re_a2 x3_im_a2 0 299764945822.76807
Cx3_im_a2 x3_im_a2 0 1.0
Gp3_im_re_a2 0 x3_im_a2 x3_re_a2 0 -299764945822.76807
Rp3_im_im_a2 0 x3_im_a2 5.362465275255059e-10
Cx4_re_a2 x4_re_a2 0 1.0
Gx4_re_a2 0 x4_re_a2 p2 0 0.1414213562373095
Fx4_re_a2 0 x4_re_a2 V2 7.0710678118654755
Rp4_re_re_a2 0 x4_re_a2 5.651020630265948e-10
Gp4_re_im_a2 0 x4_re_a2 x4_im_a2 0 295780770455.4801
Cx4_im_a2 x4_im_a2 0 1.0
Gp4_im_re_a2 0 x4_im_a2 x4_re_a2 0 -295780770455.4801
Rp4_im_im_a2 0 x4_im_a2 5.651020630265948e-10
Cx5_re_a2 x5_re_a2 0 1.0
Gx5_re_a2 0 x5_re_a2 p2 0 0.1414213562373095
Fx5_re_a2 0 x5_re_a2 V2 7.0710678118654755
Rp5_re_re_a2 0 x5_re_a2 4.4583648371353355e-11
Gp5_re_im_a2 0 x5_re_a2 x5_im_a2 0 280184551048.1205
Cx5_im_a2 x5_im_a2 0 1.0
Gp5_im_re_a2 0 x5_im_a2 x5_re_a2 0 -280184551048.1205
Rp5_im_im_a2 0 x5_im_a2 4.4583648371353355e-11
Cx6_re_a2 x6_re_a2 0 1.0
Gx6_re_a2 0 x6_re_a2 p2 0 0.1414213562373095
Fx6_re_a2 0 x6_re_a2 V2 7.0710678118654755
Rp6_re_re_a2 0 x6_re_a2 9.027710283976132e-10
Gp6_re_im_a2 0 x6_re_a2 x6_im_a2 0 284797609898.4314
Cx6_im_a2 x6_im_a2 0 1.0
Gp6_im_re_a2 0 x6_im_a2 x6_re_a2 0 -284797609898.4314
Rp6_im_im_a2 0 x6_im_a2 9.027710283976132e-10
Cx7_re_a2 x7_re_a2 0 1.0
Gx7_re_a2 0 x7_re_a2 p2 0 0.1414213562373095
Fx7_re_a2 0 x7_re_a2 V2 7.0710678118654755
Rp7_re_re_a2 0 x7_re_a2 7.771258315741444e-10
Gp7_re_im_a2 0 x7_re_a2 x7_im_a2 0 280937443543.525
Cx7_im_a2 x7_im_a2 0 1.0
Gp7_im_re_a2 0 x7_im_a2 x7_re_a2 0 -280937443543.525
Rp7_im_im_a2 0 x7_im_a2 7.771258315741444e-10
Cx8_re_a2 x8_re_a2 0 1.0
Gx8_re_a2 0 x8_re_a2 p2 0 0.1414213562373095
Fx8_re_a2 0 x8_re_a2 V2 7.0710678118654755
Rp8_re_re_a2 0 x8_re_a2 1.3252660304487296e-09
Gp8_re_im_a2 0 x8_re_a2 x8_im_a2 0 269390760843.16248
Cx8_im_a2 x8_im_a2 0 1.0
Gp8_im_re_a2 0 x8_im_a2 x8_re_a2 0 -269390760843.16248
Rp8_im_im_a2 0 x8_im_a2 1.3252660304487296e-09
Cx9_re_a2 x9_re_a2 0 1.0
Gx9_re_a2 0 x9_re_a2 p2 0 0.1414213562373095
Fx9_re_a2 0 x9_re_a2 V2 7.0710678118654755
Rp9_re_re_a2 0 x9_re_a2 8.837487410164448e-10
Gp9_re_im_a2 0 x9_re_a2 x9_im_a2 0 260736146261.56058
Cx9_im_a2 x9_im_a2 0 1.0
Gp9_im_re_a2 0 x9_im_a2 x9_re_a2 0 -260736146261.56058
Rp9_im_im_a2 0 x9_im_a2 8.837487410164448e-10
Cx10_re_a2 x10_re_a2 0 1.0
Gx10_re_a2 0 x10_re_a2 p2 0 0.1414213562373095
Fx10_re_a2 0 x10_re_a2 V2 7.0710678118654755
Rp10_re_re_a2 0 x10_re_a2 7.74337520639369e-10
Gp10_re_im_a2 0 x10_re_a2 x10_im_a2 0 246291422182.96008
Cx10_im_a2 x10_im_a2 0 1.0
Gp10_im_re_a2 0 x10_im_a2 x10_re_a2 0 -246291422182.96008
Rp10_im_im_a2 0 x10_im_a2 7.74337520639369e-10
Cx11_re_a2 x11_re_a2 0 1.0
Gx11_re_a2 0 x11_re_a2 p2 0 0.1414213562373095
Fx11_re_a2 0 x11_re_a2 V2 7.0710678118654755
Rp11_re_re_a2 0 x11_re_a2 8.390860458298588e-10
Gp11_re_im_a2 0 x11_re_a2 x11_im_a2 0 242228737451.13144
Cx11_im_a2 x11_im_a2 0 1.0
Gp11_im_re_a2 0 x11_im_a2 x11_re_a2 0 -242228737451.13144
Rp11_im_im_a2 0 x11_im_a2 8.390860458298588e-10
Cx12_re_a2 x12_re_a2 0 1.0
Gx12_re_a2 0 x12_re_a2 p2 0 0.1414213562373095
Fx12_re_a2 0 x12_re_a2 V2 7.0710678118654755
Rp12_re_re_a2 0 x12_re_a2 4.4656692854153325e-10
Gp12_re_im_a2 0 x12_re_a2 x12_im_a2 0 236640156802.20322
Cx12_im_a2 x12_im_a2 0 1.0
Gp12_im_re_a2 0 x12_im_a2 x12_re_a2 0 -236640156802.20322
Rp12_im_im_a2 0 x12_im_a2 4.4656692854153325e-10
Cx13_re_a2 x13_re_a2 0 1.0
Gx13_re_a2 0 x13_re_a2 p2 0 0.1414213562373095
Fx13_re_a2 0 x13_re_a2 V2 7.0710678118654755
Rp13_re_re_a2 0 x13_re_a2 6.602787100602715e-10
Gp13_re_im_a2 0 x13_re_a2 x13_im_a2 0 229310531843.11926
Cx13_im_a2 x13_im_a2 0 1.0
Gp13_im_re_a2 0 x13_im_a2 x13_re_a2 0 -229310531843.11926
Rp13_im_im_a2 0 x13_im_a2 6.602787100602715e-10
Cx14_re_a2 x14_re_a2 0 1.0
Gx14_re_a2 0 x14_re_a2 p2 0 0.1414213562373095
Fx14_re_a2 0 x14_re_a2 V2 7.0710678118654755
Rp14_re_re_a2 0 x14_re_a2 6.683832237932593e-10
Gp14_re_im_a2 0 x14_re_a2 x14_im_a2 0 221343536942.1764
Cx14_im_a2 x14_im_a2 0 1.0
Gp14_im_re_a2 0 x14_im_a2 x14_re_a2 0 -221343536942.1764
Rp14_im_im_a2 0 x14_im_a2 6.683832237932593e-10
Cx15_re_a2 x15_re_a2 0 1.0
Gx15_re_a2 0 x15_re_a2 p2 0 0.1414213562373095
Fx15_re_a2 0 x15_re_a2 V2 7.0710678118654755
Rp15_re_re_a2 0 x15_re_a2 7.821256797324849e-10
Gp15_re_im_a2 0 x15_re_a2 x15_im_a2 0 216900169045.56696
Cx15_im_a2 x15_im_a2 0 1.0
Gp15_im_re_a2 0 x15_im_a2 x15_re_a2 0 -216900169045.56696
Rp15_im_im_a2 0 x15_im_a2 7.821256797324849e-10
Cx16_re_a2 x16_re_a2 0 1.0
Gx16_re_a2 0 x16_re_a2 p2 0 0.1414213562373095
Fx16_re_a2 0 x16_re_a2 V2 7.0710678118654755
Rp16_re_re_a2 0 x16_re_a2 7.830440984431804e-10
Gp16_re_im_a2 0 x16_re_a2 x16_im_a2 0 205989675376.3724
Cx16_im_a2 x16_im_a2 0 1.0
Gp16_im_re_a2 0 x16_im_a2 x16_re_a2 0 -205989675376.3724
Rp16_im_im_a2 0 x16_im_a2 7.830440984431804e-10
Cx17_re_a2 x17_re_a2 0 1.0
Gx17_re_a2 0 x17_re_a2 p2 0 0.1414213562373095
Fx17_re_a2 0 x17_re_a2 V2 7.0710678118654755
Rp17_re_re_a2 0 x17_re_a2 3.6596596885047425e-10
Gp17_re_im_a2 0 x17_re_a2 x17_im_a2 0 200356736984.54144
Cx17_im_a2 x17_im_a2 0 1.0
Gp17_im_re_a2 0 x17_im_a2 x17_re_a2 0 -200356736984.54144
Rp17_im_im_a2 0 x17_im_a2 3.6596596885047425e-10
Cx18_re_a2 x18_re_a2 0 1.0
Gx18_re_a2 0 x18_re_a2 p2 0 0.1414213562373095
Fx18_re_a2 0 x18_re_a2 V2 7.0710678118654755
Rp18_re_re_a2 0 x18_re_a2 4.584479098871507e-10
Gp18_re_im_a2 0 x18_re_a2 x18_im_a2 0 194828352286.79108
Cx18_im_a2 x18_im_a2 0 1.0
Gp18_im_re_a2 0 x18_im_a2 x18_re_a2 0 -194828352286.79108
Rp18_im_im_a2 0 x18_im_a2 4.584479098871507e-10
Cx19_re_a2 x19_re_a2 0 1.0
Gx19_re_a2 0 x19_re_a2 p2 0 0.1414213562373095
Fx19_re_a2 0 x19_re_a2 V2 7.0710678118654755
Rp19_re_re_a2 0 x19_re_a2 3.2577500493070084e-10
Gp19_re_im_a2 0 x19_re_a2 x19_im_a2 0 187933840477.96106
Cx19_im_a2 x19_im_a2 0 1.0
Gp19_im_re_a2 0 x19_im_a2 x19_re_a2 0 -187933840477.96106
Rp19_im_im_a2 0 x19_im_a2 3.2577500493070084e-10
Cx20_re_a2 x20_re_a2 0 1.0
Gx20_re_a2 0 x20_re_a2 p2 0 0.1414213562373095
Fx20_re_a2 0 x20_re_a2 V2 7.0710678118654755
Rp20_re_re_a2 0 x20_re_a2 3.7030670747264964e-10
Gp20_re_im_a2 0 x20_re_a2 x20_im_a2 0 182988642847.68027
Cx20_im_a2 x20_im_a2 0 1.0
Gp20_im_re_a2 0 x20_im_a2 x20_re_a2 0 -182988642847.68027
Rp20_im_im_a2 0 x20_im_a2 3.7030670747264964e-10
Cx21_re_a2 x21_re_a2 0 1.0
Gx21_re_a2 0 x21_re_a2 p2 0 0.1414213562373095
Fx21_re_a2 0 x21_re_a2 V2 7.0710678118654755
Rp21_re_re_a2 0 x21_re_a2 4.088062182753204e-10
Gp21_re_im_a2 0 x21_re_a2 x21_im_a2 0 177633712933.48953
Cx21_im_a2 x21_im_a2 0 1.0
Gp21_im_re_a2 0 x21_im_a2 x21_re_a2 0 -177633712933.48953
Rp21_im_im_a2 0 x21_im_a2 4.088062182753204e-10
Cx22_re_a2 x22_re_a2 0 1.0
Gx22_re_a2 0 x22_re_a2 p2 0 0.1414213562373095
Fx22_re_a2 0 x22_re_a2 V2 7.0710678118654755
Rp22_re_re_a2 0 x22_re_a2 3.9909194915050626e-10
Gp22_re_im_a2 0 x22_re_a2 x22_im_a2 0 170516011194.32175
Cx22_im_a2 x22_im_a2 0 1.0
Gp22_im_re_a2 0 x22_im_a2 x22_re_a2 0 -170516011194.32175
Rp22_im_im_a2 0 x22_im_a2 3.9909194915050626e-10
Cx23_re_a2 x23_re_a2 0 1.0
Gx23_re_a2 0 x23_re_a2 p2 0 0.1414213562373095
Fx23_re_a2 0 x23_re_a2 V2 7.0710678118654755
Rp23_re_re_a2 0 x23_re_a2 3.5380163711038947e-10
Gp23_re_im_a2 0 x23_re_a2 x23_im_a2 0 164953816321.0323
Cx23_im_a2 x23_im_a2 0 1.0
Gp23_im_re_a2 0 x23_im_a2 x23_re_a2 0 -164953816321.0323
Rp23_im_im_a2 0 x23_im_a2 3.5380163711038947e-10
Cx24_re_a2 x24_re_a2 0 1.0
Gx24_re_a2 0 x24_re_a2 p2 0 0.1414213562373095
Fx24_re_a2 0 x24_re_a2 V2 7.0710678118654755
Rp24_re_re_a2 0 x24_re_a2 5.039130565519937e-10
Gp24_re_im_a2 0 x24_re_a2 x24_im_a2 0 159173864190.63727
Cx24_im_a2 x24_im_a2 0 1.0
Gp24_im_re_a2 0 x24_im_a2 x24_re_a2 0 -159173864190.63727
Rp24_im_im_a2 0 x24_im_a2 5.039130565519937e-10
Cx25_re_a2 x25_re_a2 0 1.0
Gx25_re_a2 0 x25_re_a2 p2 0 0.1414213562373095
Fx25_re_a2 0 x25_re_a2 V2 7.0710678118654755
Rp25_re_re_a2 0 x25_re_a2 4.289339569151169e-10
Gp25_re_im_a2 0 x25_re_a2 x25_im_a2 0 152473894102.3021
Cx25_im_a2 x25_im_a2 0 1.0
Gp25_im_re_a2 0 x25_im_a2 x25_re_a2 0 -152473894102.3021
Rp25_im_im_a2 0 x25_im_a2 4.289339569151169e-10
Cx26_re_a2 x26_re_a2 0 1.0
Gx26_re_a2 0 x26_re_a2 p2 0 0.1414213562373095
Fx26_re_a2 0 x26_re_a2 V2 7.0710678118654755
Rp26_re_re_a2 0 x26_re_a2 5.604106708721165e-10
Gp26_re_im_a2 0 x26_re_a2 x26_im_a2 0 143458007374.04828
Cx26_im_a2 x26_im_a2 0 1.0
Gp26_im_re_a2 0 x26_im_a2 x26_re_a2 0 -143458007374.04828
Rp26_im_im_a2 0 x26_im_a2 5.604106708721165e-10
Cx27_re_a2 x27_re_a2 0 1.0
Gx27_re_a2 0 x27_re_a2 p2 0 0.1414213562373095
Fx27_re_a2 0 x27_re_a2 V2 7.0710678118654755
Rp27_re_re_a2 0 x27_re_a2 4.0415824417463693e-10
Gp27_re_im_a2 0 x27_re_a2 x27_im_a2 0 139191009718.3968
Cx27_im_a2 x27_im_a2 0 1.0
Gp27_im_re_a2 0 x27_im_a2 x27_re_a2 0 -139191009718.3968
Rp27_im_im_a2 0 x27_im_a2 4.0415824417463693e-10
Cx28_re_a2 x28_re_a2 0 1.0
Gx28_re_a2 0 x28_re_a2 p2 0 0.1414213562373095
Fx28_re_a2 0 x28_re_a2 V2 7.0710678118654755
Rp28_re_re_a2 0 x28_re_a2 5.515497777837109e-10
Gp28_re_im_a2 0 x28_re_a2 x28_im_a2 0 135717785993.89098
Cx28_im_a2 x28_im_a2 0 1.0
Gp28_im_re_a2 0 x28_im_a2 x28_re_a2 0 -135717785993.89098
Rp28_im_im_a2 0 x28_im_a2 5.515497777837109e-10
Cx29_re_a2 x29_re_a2 0 1.0
Gx29_re_a2 0 x29_re_a2 p2 0 0.1414213562373095
Fx29_re_a2 0 x29_re_a2 V2 7.0710678118654755
Rp29_re_re_a2 0 x29_re_a2 5.385911467068673e-10
Gp29_re_im_a2 0 x29_re_a2 x29_im_a2 0 130198859531.93167
Cx29_im_a2 x29_im_a2 0 1.0
Gp29_im_re_a2 0 x29_im_a2 x29_re_a2 0 -130198859531.93167
Rp29_im_im_a2 0 x29_im_a2 5.385911467068673e-10
Cx30_re_a2 x30_re_a2 0 1.0
Gx30_re_a2 0 x30_re_a2 p2 0 0.1414213562373095
Fx30_re_a2 0 x30_re_a2 V2 7.0710678118654755
Rp30_re_re_a2 0 x30_re_a2 1.293631499869189e-10
Gp30_re_im_a2 0 x30_re_a2 x30_im_a2 0 125026933526.9245
Cx30_im_a2 x30_im_a2 0 1.0
Gp30_im_re_a2 0 x30_im_a2 x30_re_a2 0 -125026933526.9245
Rp30_im_im_a2 0 x30_im_a2 1.293631499869189e-10
Cx31_re_a2 x31_re_a2 0 1.0
Gx31_re_a2 0 x31_re_a2 p2 0 0.1414213562373095
Fx31_re_a2 0 x31_re_a2 V2 7.0710678118654755
Rp31_re_re_a2 0 x31_re_a2 4.4598309986159816e-10
Gp31_re_im_a2 0 x31_re_a2 x31_im_a2 0 125249512856.41823
Cx31_im_a2 x31_im_a2 0 1.0
Gp31_im_re_a2 0 x31_im_a2 x31_re_a2 0 -125249512856.41823
Rp31_im_im_a2 0 x31_im_a2 4.4598309986159816e-10
Cx32_re_a2 x32_re_a2 0 1.0
Gx32_re_a2 0 x32_re_a2 p2 0 0.1414213562373095
Fx32_re_a2 0 x32_re_a2 V2 7.0710678118654755
Rp32_re_re_a2 0 x32_re_a2 6.806449337893251e-10
Gp32_re_im_a2 0 x32_re_a2 x32_im_a2 0 114377525421.56393
Cx32_im_a2 x32_im_a2 0 1.0
Gp32_im_re_a2 0 x32_im_a2 x32_re_a2 0 -114377525421.56393
Rp32_im_im_a2 0 x32_im_a2 6.806449337893251e-10
Cx33_re_a2 x33_re_a2 0 1.0
Gx33_re_a2 0 x33_re_a2 p2 0 0.1414213562373095
Fx33_re_a2 0 x33_re_a2 V2 7.0710678118654755
Rp33_re_re_a2 0 x33_re_a2 6.827975557481133e-10
Gp33_re_im_a2 0 x33_re_a2 x33_im_a2 0 109880322668.63147
Cx33_im_a2 x33_im_a2 0 1.0
Gp33_im_re_a2 0 x33_im_a2 x33_re_a2 0 -109880322668.63147
Rp33_im_im_a2 0 x33_im_a2 6.827975557481133e-10
Cx34_re_a2 x34_re_a2 0 1.0
Gx34_re_a2 0 x34_re_a2 p2 0 0.1414213562373095
Fx34_re_a2 0 x34_re_a2 V2 7.0710678118654755
Rp34_re_re_a2 0 x34_re_a2 6.414613283370872e-10
Gp34_re_im_a2 0 x34_re_a2 x34_im_a2 0 100363561795.05267
Cx34_im_a2 x34_im_a2 0 1.0
Gp34_im_re_a2 0 x34_im_a2 x34_re_a2 0 -100363561795.05267
Rp34_im_im_a2 0 x34_im_a2 6.414613283370872e-10
Cx35_re_a2 x35_re_a2 0 1.0
Gx35_re_a2 0 x35_re_a2 p2 0 0.1414213562373095
Fx35_re_a2 0 x35_re_a2 V2 7.0710678118654755
Rp35_re_re_a2 0 x35_re_a2 5.255745869778509e-10
Gp35_re_im_a2 0 x35_re_a2 x35_im_a2 0 95922025504.53201
Cx35_im_a2 x35_im_a2 0 1.0
Gp35_im_re_a2 0 x35_im_a2 x35_re_a2 0 -95922025504.53201
Rp35_im_im_a2 0 x35_im_a2 5.255745869778509e-10
Cx36_re_a2 x36_re_a2 0 1.0
Gx36_re_a2 0 x36_re_a2 p2 0 0.1414213562373095
Fx36_re_a2 0 x36_re_a2 V2 7.0710678118654755
Rp36_re_re_a2 0 x36_re_a2 4.701845418472811e-10
Gp36_re_im_a2 0 x36_re_a2 x36_im_a2 0 91827204426.0559
Cx36_im_a2 x36_im_a2 0 1.0
Gp36_im_re_a2 0 x36_im_a2 x36_re_a2 0 -91827204426.0559
Rp36_im_im_a2 0 x36_im_a2 4.701845418472811e-10
Cx37_re_a2 x37_re_a2 0 1.0
Gx37_re_a2 0 x37_re_a2 p2 0 0.1414213562373095
Fx37_re_a2 0 x37_re_a2 V2 7.0710678118654755
Rp37_re_re_a2 0 x37_re_a2 5.1986573840207194e-11
Gp37_re_im_a2 0 x37_re_a2 x37_im_a2 0 72397845044.52003
Cx37_im_a2 x37_im_a2 0 1.0
Gp37_im_re_a2 0 x37_im_a2 x37_re_a2 0 -72397845044.52003
Rp37_im_im_a2 0 x37_im_a2 5.1986573840207194e-11
Cx38_re_a2 x38_re_a2 0 1.0
Gx38_re_a2 0 x38_re_a2 p2 0 0.1414213562373095
Fx38_re_a2 0 x38_re_a2 V2 7.0710678118654755
Rp38_re_re_a2 0 x38_re_a2 6.266691087283841e-10
Gp38_re_im_a2 0 x38_re_a2 x38_im_a2 0 87242951630.81523
Cx38_im_a2 x38_im_a2 0 1.0
Gp38_im_re_a2 0 x38_im_a2 x38_re_a2 0 -87242951630.81523
Rp38_im_im_a2 0 x38_im_a2 6.266691087283841e-10
Cx39_re_a2 x39_re_a2 0 1.0
Gx39_re_a2 0 x39_re_a2 p2 0 0.1414213562373095
Fx39_re_a2 0 x39_re_a2 V2 7.0710678118654755
Rp39_re_re_a2 0 x39_re_a2 5.234864343640884e-10
Gp39_re_im_a2 0 x39_re_a2 x39_im_a2 0 82858757195.85092
Cx39_im_a2 x39_im_a2 0 1.0
Gp39_im_re_a2 0 x39_im_a2 x39_re_a2 0 -82858757195.85092
Rp39_im_im_a2 0 x39_im_a2 5.234864343640884e-10
Cx40_re_a2 x40_re_a2 0 1.0
Gx40_re_a2 0 x40_re_a2 p2 0 0.1414213562373095
Fx40_re_a2 0 x40_re_a2 V2 7.0710678118654755
Rp40_re_re_a2 0 x40_re_a2 5.871156006436874e-10
Gp40_re_im_a2 0 x40_re_a2 x40_im_a2 0 78507674910.57098
Cx40_im_a2 x40_im_a2 0 1.0
Gp40_im_re_a2 0 x40_im_a2 x40_re_a2 0 -78507674910.57098
Rp40_im_im_a2 0 x40_im_a2 5.871156006436874e-10
Cx41_re_a2 x41_re_a2 0 1.0
Gx41_re_a2 0 x41_re_a2 p2 0 0.1414213562373095
Fx41_re_a2 0 x41_re_a2 V2 7.0710678118654755
Rp41_re_re_a2 0 x41_re_a2 7.362920812502898e-10
Gp41_re_im_a2 0 x41_re_a2 x41_im_a2 0 53898762948.71844
Cx41_im_a2 x41_im_a2 0 1.0
Gp41_im_re_a2 0 x41_im_a2 x41_re_a2 0 -53898762948.71844
Rp41_im_im_a2 0 x41_im_a2 7.362920812502898e-10
Cx42_re_a2 x42_re_a2 0 1.0
Gx42_re_a2 0 x42_re_a2 p2 0 0.1414213562373095
Fx42_re_a2 0 x42_re_a2 V2 7.0710678118654755
Rp42_re_re_a2 0 x42_re_a2 6.83072510187094e-10
Gp42_re_im_a2 0 x42_re_a2 x42_im_a2 0 49596203552.090675
Cx42_im_a2 x42_im_a2 0 1.0
Gp42_im_re_a2 0 x42_im_a2 x42_re_a2 0 -49596203552.090675
Rp42_im_im_a2 0 x42_im_a2 6.83072510187094e-10
Cx43_re_a2 x43_re_a2 0 1.0
Gx43_re_a2 0 x43_re_a2 p2 0 0.1414213562373095
Fx43_re_a2 0 x43_re_a2 V2 7.0710678118654755
Rp43_re_re_a2 0 x43_re_a2 7.886851854703573e-10
Gp43_re_im_a2 0 x43_re_a2 x43_im_a2 0 33914448806.74464
Cx43_im_a2 x43_im_a2 0 1.0
Gp43_im_re_a2 0 x43_im_a2 x43_re_a2 0 -33914448806.74464
Rp43_im_im_a2 0 x43_im_a2 7.886851854703573e-10
Cx44_re_a2 x44_re_a2 0 1.0
Gx44_re_a2 0 x44_re_a2 p2 0 0.1414213562373095
Fx44_re_a2 0 x44_re_a2 V2 7.0710678118654755
Rp44_re_re_a2 0 x44_re_a2 6.90773635036418e-10
Gp44_re_im_a2 0 x44_re_a2 x44_im_a2 0 28461055845.680824
Cx44_im_a2 x44_im_a2 0 1.0
Gp44_im_re_a2 0 x44_im_a2 x44_re_a2 0 -28461055845.680824
Rp44_im_im_a2 0 x44_im_a2 6.90773635036418e-10
Cx45_re_a2 x45_re_a2 0 1.0
Gx45_re_a2 0 x45_re_a2 p2 0 0.1414213562373095
Fx45_re_a2 0 x45_re_a2 V2 7.0710678118654755
Rp45_re_re_a2 0 x45_re_a2 6.80191910067349e-10
Gp45_re_im_a2 0 x45_re_a2 x45_im_a2 0 24097859368.009228
Cx45_im_a2 x45_im_a2 0 1.0
Gp45_im_re_a2 0 x45_im_a2 x45_re_a2 0 -24097859368.009228
Rp45_im_im_a2 0 x45_im_a2 6.80191910067349e-10
Cx46_re_a2 x46_re_a2 0 1.0
Gx46_re_a2 0 x46_re_a2 p2 0 0.1414213562373095
Fx46_re_a2 0 x46_re_a2 V2 7.0710678118654755
Rp46_re_re_a2 0 x46_re_a2 3.3632515940909853e-10
Gp46_re_im_a2 0 x46_re_a2 x46_im_a2 0 17535003925.97815
Cx46_im_a2 x46_im_a2 0 1.0
Gp46_im_re_a2 0 x46_im_a2 x46_re_a2 0 -17535003925.97815
Rp46_im_im_a2 0 x46_im_a2 3.3632515940909853e-10
Cx47_re_a2 x47_re_a2 0 1.0
Gx47_re_a2 0 x47_re_a2 p2 0 0.1414213562373095
Fx47_re_a2 0 x47_re_a2 V2 7.0710678118654755
Rp47_re_re_a2 0 x47_re_a2 9.629414892146456e-10
Gp47_re_im_a2 0 x47_re_a2 x47_im_a2 0 11715090574.045237
Cx47_im_a2 x47_im_a2 0 1.0
Gp47_im_re_a2 0 x47_im_a2 x47_re_a2 0 -11715090574.045237
Rp47_im_im_a2 0 x47_im_a2 9.629414892146456e-10
Cx48_re_a2 x48_re_a2 0 1.0
Gx48_re_a2 0 x48_re_a2 p2 0 0.1414213562373095
Fx48_re_a2 0 x48_re_a2 V2 7.0710678118654755
Rp48_re_re_a2 0 x48_re_a2 8.037389283921146e-10
Gp48_re_im_a2 0 x48_re_a2 x48_im_a2 0 8411555387.1175995
Cx48_im_a2 x48_im_a2 0 1.0
Gp48_im_re_a2 0 x48_im_a2 x48_re_a2 0 -8411555387.1175995
Rp48_im_im_a2 0 x48_im_a2 8.037389283921146e-10
Cx49_re_a2 x49_re_a2 0 1.0
Gx49_re_a2 0 x49_re_a2 p2 0 0.1414213562373095
Fx49_re_a2 0 x49_re_a2 V2 7.0710678118654755
Rp49_re_re_a2 0 x49_re_a2 2.3953032926638584e-09
Gp49_re_im_a2 0 x49_re_a2 x49_im_a2 0 7281971191.968741
Cx49_im_a2 x49_im_a2 0 1.0
Gp49_im_re_a2 0 x49_im_a2 x49_re_a2 0 -7281971191.968741
Rp49_im_im_a2 0 x49_im_a2 2.3953032926638584e-09
Cx50_re_a2 x50_re_a2 0 1.0
Gx50_re_a2 0 x50_re_a2 p2 0 0.1414213562373095
Fx50_re_a2 0 x50_re_a2 V2 7.0710678118654755
Rp50_re_re_a2 0 x50_re_a2 9.291538099627055e-09
Gp50_re_im_a2 0 x50_re_a2 x50_im_a2 0 5485192888.061847
Cx50_im_a2 x50_im_a2 0 1.0
Gp50_im_re_a2 0 x50_im_a2 x50_re_a2 0 -5485192888.061847
Rp50_im_im_a2 0 x50_im_a2 9.291538099627055e-09
Cx51_re_a2 x51_re_a2 0 1.0
Gx51_re_a2 0 x51_re_a2 p2 0 0.1414213562373095
Fx51_re_a2 0 x51_re_a2 V2 7.0710678118654755
Rp51_re_re_a2 0 x51_re_a2 1.1361341983747998e-08
Gp51_re_im_a2 0 x51_re_a2 x51_im_a2 0 4208225203.7586317
Cx51_im_a2 x51_im_a2 0 1.0
Gp51_im_re_a2 0 x51_im_a2 x51_re_a2 0 -4208225203.7586317
Rp51_im_im_a2 0 x51_im_a2 1.1361341983747998e-08
Cx52_re_a2 x52_re_a2 0 1.0
Gx52_re_a2 0 x52_re_a2 p2 0 0.1414213562373095
Fx52_re_a2 0 x52_re_a2 V2 7.0710678118654755
Rp52_re_re_a2 0 x52_re_a2 6.593416593325721e-09
Gp52_re_im_a2 0 x52_re_a2 x52_im_a2 0 3907713961.770896
Cx52_im_a2 x52_im_a2 0 1.0
Gp52_im_re_a2 0 x52_im_a2 x52_re_a2 0 -3907713961.770896
Rp52_im_im_a2 0 x52_im_a2 6.593416593325721e-09
Cx53_re_a2 x53_re_a2 0 1.0
Gx53_re_a2 0 x53_re_a2 p2 0 0.1414213562373095
Fx53_re_a2 0 x53_re_a2 V2 7.0710678118654755
Rp53_re_re_a2 0 x53_re_a2 4.598865760619702e-09
Gp53_re_im_a2 0 x53_re_a2 x53_im_a2 0 3138989640.311349
Cx53_im_a2 x53_im_a2 0 1.0
Gp53_im_re_a2 0 x53_im_a2 x53_re_a2 0 -3138989640.311349
Rp53_im_im_a2 0 x53_im_a2 4.598865760619702e-09
Cx54_re_a2 x54_re_a2 0 1.0
Gx54_re_a2 0 x54_re_a2 p2 0 0.1414213562373095
Fx54_re_a2 0 x54_re_a2 V2 7.0710678118654755
Rp54_re_re_a2 0 x54_re_a2 5.013329113974378e-09
Gp54_re_im_a2 0 x54_re_a2 x54_im_a2 0 2763239017.283009
Cx54_im_a2 x54_im_a2 0 1.0
Gp54_im_re_a2 0 x54_im_a2 x54_re_a2 0 -2763239017.283009
Rp54_im_im_a2 0 x54_im_a2 5.013329113974378e-09
Cx55_re_a2 x55_re_a2 0 1.0
Gx55_re_a2 0 x55_re_a2 p2 0 0.1414213562373095
Fx55_re_a2 0 x55_re_a2 V2 7.0710678118654755
Rp55_re_re_a2 0 x55_re_a2 5.489391819401233e-09
Gp55_re_im_a2 0 x55_re_a2 x55_im_a2 0 2337692824.826442
Cx55_im_a2 x55_im_a2 0 1.0
Gp55_im_re_a2 0 x55_im_a2 x55_re_a2 0 -2337692824.826442
Rp55_im_im_a2 0 x55_im_a2 5.489391819401233e-09
Cx56_re_a2 x56_re_a2 0 1.0
Gx56_re_a2 0 x56_re_a2 p2 0 0.1414213562373095
Fx56_re_a2 0 x56_re_a2 V2 7.0710678118654755
Rp56_re_re_a2 0 x56_re_a2 5.715836849677958e-09
Gp56_re_im_a2 0 x56_re_a2 x56_im_a2 0 1907462400.4905782
Cx56_im_a2 x56_im_a2 0 1.0
Gp56_im_re_a2 0 x56_im_a2 x56_re_a2 0 -1907462400.4905782
Rp56_im_im_a2 0 x56_im_a2 5.715836849677958e-09
Cx57_re_a2 x57_re_a2 0 1.0
Gx57_re_a2 0 x57_re_a2 p2 0 0.1414213562373095
Fx57_re_a2 0 x57_re_a2 V2 7.0710678118654755
Rp57_re_re_a2 0 x57_re_a2 5.740354751724126e-09
Gp57_re_im_a2 0 x57_re_a2 x57_im_a2 0 1043629713.8561413
Cx57_im_a2 x57_im_a2 0 1.0
Gp57_im_re_a2 0 x57_im_a2 x57_re_a2 0 -1043629713.8561413
Rp57_im_im_a2 0 x57_im_a2 5.740354751724126e-09
Cx58_re_a2 x58_re_a2 0 1.0
Gx58_re_a2 0 x58_re_a2 p2 0 0.1414213562373095
Fx58_re_a2 0 x58_re_a2 V2 7.0710678118654755
Rp58_re_re_a2 0 x58_re_a2 5.783268392817006e-09
Gp58_re_im_a2 0 x58_re_a2 x58_im_a2 0 1474144465.2759433
Cx58_im_a2 x58_im_a2 0 1.0
Gp58_im_re_a2 0 x58_im_a2 x58_re_a2 0 -1474144465.2759433
Rp58_im_im_a2 0 x58_im_a2 5.783268392817006e-09
Cx59_re_a2 x59_re_a2 0 1.0
Gx59_re_a2 0 x59_re_a2 p2 0 0.1414213562373095
Fx59_re_a2 0 x59_re_a2 V2 7.0710678118654755
Rp59_re_re_a2 0 x59_re_a2 5.734252219761168e-09
Gp59_re_im_a2 0 x59_re_a2 x59_im_a2 0 201137530.81086907
Cx59_im_a2 x59_im_a2 0 1.0
Gp59_im_re_a2 0 x59_im_a2 x59_re_a2 0 -201137530.81086907
Rp59_im_im_a2 0 x59_im_a2 5.734252219761168e-09
Cx60_re_a2 x60_re_a2 0 1.0
Gx60_re_a2 0 x60_re_a2 p2 0 0.1414213562373095
Fx60_re_a2 0 x60_re_a2 V2 7.0710678118654755
Rp60_re_re_a2 0 x60_re_a2 5.652786094011291e-09
Gp60_re_im_a2 0 x60_re_a2 x60_im_a2 0 618651646.662869
Cx60_im_a2 x60_im_a2 0 1.0
Gp60_im_re_a2 0 x60_im_a2 x60_re_a2 0 -618651646.662869
Rp60_im_im_a2 0 x60_im_a2 5.652786094011291e-09
*
* Port network for port 3
V3 p3 s3 0
R3 s3 0 50.0
Gd3_1 0 s3 p1 0 0.00020505717188670772
Fd3_1 0 s3 V1 0.010252858594335387
Gr1_re_3_1 0 s3 x1_re_a1 0 18461356858.898106
Gr1_im_3_1 0 s3 x1_im_a1 0 -26026614438.073547
Gr2_re_3_1 0 s3 x2_re_a1 0 3407578006004840.0
Gr2_im_3_1 0 s3 x2_im_a1 0 -2766649689375692.0
Gr3_re_3_1 0 s3 x3_re_a1 0 -4.1447231307997944e+16
Gr3_im_3_1 0 s3 x3_im_a1 0 -3.2210170023067624e+16
Gr4_re_3_1 0 s3 x4_re_a1 0 6.164424677441935e+16
Gr4_im_3_1 0 s3 x4_im_a1 0 1.360307954337904e+17
Gr5_re_3_1 0 s3 x5_re_a1 0 6.597371757307652e+17
Gr5_im_3_1 0 s3 x5_im_a1 0 -1.2384482213934674e+17
Gr6_re_3_1 0 s3 x6_re_a1 0 6.30386162043804e+16
Gr6_im_3_1 0 s3 x6_im_a1 0 6.76743047990307e+17
Gr7_re_3_1 0 s3 x7_re_a1 0 6.069476043614369e+17
Gr7_im_3_1 0 s3 x7_im_a1 0 -1.7050146498429066e+18
Gr8_re_3_1 0 s3 x8_re_a1 0 1.4600444841011912e+18
Gr8_im_3_1 0 s3 x8_im_a1 0 -1.3847216021018365e+18
Gr9_re_3_1 0 s3 x9_re_a1 0 -3.950699477175882e+18
Gr9_im_3_1 0 s3 x9_im_a1 0 -1.737132968607529e+17
Gr10_re_3_1 0 s3 x10_re_a1 0 -4.83048691934188e+19
Gr10_im_3_1 0 s3 x10_im_a1 0 -1.5101970550172338e+19
Gr11_re_3_1 0 s3 x11_re_a1 0 -1.485879728525292e+19
Gr11_im_3_1 0 s3 x11_im_a1 0 3.3454149785905074e+19
Gr12_re_3_1 0 s3 x12_re_a1 0 1.4664206752584417e+20
Gr12_im_3_1 0 s3 x12_im_a1 0 2.874490687735481e+18
Gr13_re_3_1 0 s3 x13_re_a1 0 -3.739810450243648e+19
Gr13_im_3_1 0 s3 x13_im_a1 0 -2.813048350000531e+19
Gr14_re_3_1 0 s3 x14_re_a1 0 -2.2161313281151615e+19
Gr14_im_3_1 0 s3 x14_im_a1 0 4.529236386885913e+18
Gr15_re_3_1 0 s3 x15_re_a1 0 -2.9446951030554448e+19
Gr15_im_3_1 0 s3 x15_im_a1 0 -1.842787800108623e+19
Gr16_re_3_1 0 s3 x16_re_a1 0 -8.340419725565547e+19
Gr16_im_3_1 0 s3 x16_im_a1 0 -4.207155269602386e+19
Gr17_re_3_1 0 s3 x17_re_a1 0 3.268194812356808e+19
Gr17_im_3_1 0 s3 x17_im_a1 0 6.241883810219769e+19
Gr18_re_3_1 0 s3 x18_re_a1 0 -2.0419623845485687e+19
Gr18_im_3_1 0 s3 x18_im_a1 0 1.1917688851045596e+18
Gr19_re_3_1 0 s3 x19_re_a1 0 9.286960255548337e+19
Gr19_im_3_1 0 s3 x19_im_a1 0 5.258929630698138e+19
Gr20_re_3_1 0 s3 x20_re_a1 0 -2.203280137559397e+18
Gr20_im_3_1 0 s3 x20_im_a1 0 5.671574141271677e+16
Gr21_re_3_1 0 s3 x21_re_a1 0 8.564525404454635e+19
Gr21_im_3_1 0 s3 x21_im_a1 0 -1.1600612030778986e+19
Gr22_re_3_1 0 s3 x22_re_a1 0 -2.7416602179790307e+19
Gr22_im_3_1 0 s3 x22_im_a1 0 -1.7187227716309539e+19
Gr23_re_3_1 0 s3 x23_re_a1 0 3.217591208438743e+19
Gr23_im_3_1 0 s3 x23_im_a1 0 -3.191280660314609e+19
Gr24_re_3_1 0 s3 x24_re_a1 0 -5.8319456407461265e+19
Gr24_im_3_1 0 s3 x24_im_a1 0 -1.8272536232103798e+18
Gr25_re_3_1 0 s3 x25_re_a1 0 -1.703933161055037e+18
Gr25_im_3_1 0 s3 x25_im_a1 0 -2.1171437372445446e+19
Gr26_re_3_1 0 s3 x26_re_a1 0 -9.14409101885928e+19
Gr26_im_3_1 0 s3 x26_im_a1 0 -3.4283449971475964e+19
Gr27_re_3_1 0 s3 x27_re_a1 0 -6.551458084826842e+18
Gr27_im_3_1 0 s3 x27_im_a1 0 -4.4890314302146304e+18
Gr28_re_3_1 0 s3 x28_re_a1 0 -1.509353042248357e+19
Gr28_im_3_1 0 s3 x28_im_a1 0 2.0886099896908894e+19
Gr29_re_3_1 0 s3 x29_re_a1 0 -4.552600748206594e+19
Gr29_im_3_1 0 s3 x29_im_a1 0 -3.6779780437841625e+19
Gr30_re_3_1 0 s3 x30_re_a1 0 -2.027609161388473e+19
Gr30_im_3_1 0 s3 x30_im_a1 0 1.042588729092371e+20
Gr31_re_3_1 0 s3 x31_re_a1 0 4.715467397914782e+19
Gr31_im_3_1 0 s3 x31_im_a1 0 1.5165131244637178e+19
Gr32_re_3_1 0 s3 x32_re_a1 0 2.0128108245101953e+19
Gr32_im_3_1 0 s3 x32_im_a1 0 -1.2704762187855933e+19
Gr33_re_3_1 0 s3 x33_re_a1 0 3.6468174436831445e+19
Gr33_im_3_1 0 s3 x33_im_a1 0 2.8132515569708536e+19
Gr34_re_3_1 0 s3 x34_re_a1 0 5.672568360784721e+19
Gr34_im_3_1 0 s3 x34_im_a1 0 1.3950339924103328e+19
Gr35_re_3_1 0 s3 x35_re_a1 0 2.3179319033616286e+19
Gr35_im_3_1 0 s3 x35_im_a1 0 2.9137000785376567e+19
Gr36_re_3_1 0 s3 x36_re_a1 0 5.3133262613788096e+17
Gr36_im_3_1 0 s3 x36_im_a1 0 -1.2138644160681267e+19
Gr37_re_3_1 0 s3 x37_re_a1 0 -1.3419021458342273e+20
Gr37_im_3_1 0 s3 x37_im_a1 0 -1.0682546108680641e+20
Gr38_re_3_1 0 s3 x38_re_a1 0 4.662532264036771e+19
Gr38_im_3_1 0 s3 x38_im_a1 0 2.5121627886258803e+19
Gr39_re_3_1 0 s3 x39_re_a1 0 6.873108071113665e+18
Gr39_im_3_1 0 s3 x39_im_a1 0 2.498318829570497e+19
Gr40_re_3_1 0 s3 x40_re_a1 0 6.47791670407705e+18
Gr40_im_3_1 0 s3 x40_im_a1 0 -4.7348997782067446e+19
Gr41_re_3_1 0 s3 x41_re_a1 0 -1.9587926950314955e+19
Gr41_im_3_1 0 s3 x41_im_a1 0 3.3649302138796335e+19
Gr42_re_3_1 0 s3 x42_re_a1 0 1.3097532283269464e+19
Gr42_im_3_1 0 s3 x42_im_a1 0 -1.5079669350239003e+19
Gr43_re_3_1 0 s3 x43_re_a1 0 -3.830660023155014e+19
Gr43_im_3_1 0 s3 x43_im_a1 0 -4.100476991810986e+18
Gr44_re_3_1 0 s3 x44_re_a1 0 -1.905065471562846e+19
Gr44_im_3_1 0 s3 x44_im_a1 0 2.219597516668417e+19
Gr45_re_3_1 0 s3 x45_re_a1 0 -3.756758033490143e+19
Gr45_im_3_1 0 s3 x45_im_a1 0 6.551635953581896e+17
Gr46_re_3_1 0 s3 x46_re_a1 0 3.837251400634776e+19
Gr46_im_3_1 0 s3 x46_im_a1 0 2.464495186482059e+19
Gr47_re_3_1 0 s3 x47_re_a1 0 -3.1275848081648095e+19
Gr47_im_3_1 0 s3 x47_im_a1 0 1.6074503055618642e+19
Gr48_re_3_1 0 s3 x48_re_a1 0 -1.861323260679481e+19
Gr48_im_3_1 0 s3 x48_im_a1 0 1.3742958341380503e+18
Gr49_re_3_1 0 s3 x49_re_a1 0 -1.1104531715857758e+19
Gr49_im_3_1 0 s3 x49_im_a1 0 -4.653277677431428e+18
Gr50_re_3_1 0 s3 x50_re_a1 0 5.134356211767823e+18
Gr50_im_3_1 0 s3 x50_im_a1 0 -3.3065349224654013e+18
Gr51_re_3_1 0 s3 x51_re_a1 0 1.5443315132091118e+19
Gr51_im_3_1 0 s3 x51_im_a1 0 -1.6323698953368067e+18
Gr52_re_3_1 0 s3 x52_re_a1 0 1.7247627791034374e+19
Gr52_im_3_1 0 s3 x52_im_a1 0 -1.2832964825960323e+18
Gr53_re_3_1 0 s3 x53_re_a1 0 2.0886666914219516e+19
Gr53_im_3_1 0 s3 x53_im_a1 0 -6.636967343071164e+17
Gr54_re_3_1 0 s3 x54_re_a1 0 2.229981926190728e+19
Gr54_im_3_1 0 s3 x54_im_a1 0 -4.629421677388295e+17
Gr55_re_3_1 0 s3 x55_re_a1 0 2.2984610201215955e+19
Gr55_im_3_1 0 s3 x55_im_a1 0 -2.8656635516359594e+17
Gr56_re_3_1 0 s3 x56_re_a1 0 2.148442292263044e+19
Gr56_im_3_1 0 s3 x56_im_a1 0 -1.5836496632557178e+17
Gr57_re_3_1 0 s3 x57_re_a1 0 7.016066838028185e+18
Gr57_im_3_1 0 s3 x57_im_a1 0 -2.7243481430208868e+16
Gr58_re_3_1 0 s3 x58_re_a1 0 1.599388359691453e+19
Gr58_im_3_1 0 s3 x58_im_a1 0 -7.446363770002971e+16
Gr59_re_3_1 0 s3 x59_re_a1 0 3.733833112710406e+16
Gr59_im_3_1 0 s3 x59_im_a1 0 -571427129635910.0
Gr60_re_3_1 0 s3 x60_re_a1 0 1.182465235280676e+18
Gr60_im_3_1 0 s3 x60_im_a1 0 -6296331082378046.0
Gd3_2 0 s3 p2 0 1.1987799555303609e-06
Fd3_2 0 s3 V2 5.993899777651805e-05
Gr1_re_3_2 0 s3 x1_re_a2 0 17528224739.752617
Gr1_im_3_2 0 s3 x1_im_a2 0 -25722624754.70508
Gr2_re_3_2 0 s3 x2_re_a2 0 3291438694278958.5
Gr2_im_3_2 0 s3 x2_im_a2 0 -2731591404466787.5
Gr3_re_3_2 0 s3 x3_re_a2 0 -4.070757223333958e+16
Gr3_im_3_2 0 s3 x3_im_a2 0 -3.0966648942367536e+16
Gr4_re_3_2 0 s3 x4_re_a2 0 6.136451140950535e+16
Gr4_im_3_2 0 s3 x4_im_a2 0 1.3193028262552635e+17
Gr5_re_3_2 0 s3 x5_re_a2 0 6.427854627172604e+17
Gr5_im_3_2 0 s3 x5_im_a2 0 -1.2570686383505933e+17
Gr6_re_3_2 0 s3 x6_re_a2 0 6.716215800442614e+16
Gr6_im_3_2 0 s3 x6_im_a2 0 6.585135967255886e+17
Gr7_re_3_2 0 s3 x7_re_a2 0 5.771249897485448e+17
Gr7_im_3_2 0 s3 x7_im_a2 0 -1.665244981180432e+18
Gr8_re_3_2 0 s3 x8_re_a2 0 1.4113813048680998e+18
Gr8_im_3_2 0 s3 x8_im_a2 0 -1.3582980586486812e+18
Gr9_re_3_2 0 s3 x9_re_a2 0 -3.845990133698231e+18
Gr9_im_3_2 0 s3 x9_im_a2 0 -1.4401805752499546e+17
Gr10_re_3_2 0 s3 x10_re_a2 0 -4.706741270651561e+19
Gr10_im_3_2 0 s3 x10_im_a2 0 -1.4449588955424844e+19
Gr11_re_3_2 0 s3 x11_re_a2 0 -1.429926955579209e+19
Gr11_im_3_2 0 s3 x11_im_a2 0 3.2608147260498694e+19
Gr12_re_3_2 0 s3 x12_re_a2 0 1.4263562411403724e+20
Gr12_im_3_2 0 s3 x12_im_a2 0 2.2285476278694467e+18
Gr13_re_3_2 0 s3 x13_re_a2 0 -3.642451095514782e+19
Gr13_im_3_2 0 s3 x13_im_a2 0 -2.7251318005932544e+19
Gr14_re_3_2 0 s3 x14_re_a2 0 -2.145667517863767e+19
Gr14_im_3_2 0 s3 x14_im_a2 0 4.211001761859635e+18
Gr15_re_3_2 0 s3 x15_re_a2 0 -2.8812348504759718e+19
Gr15_im_3_2 0 s3 x15_im_a2 0 -1.7638014495946246e+19
Gr16_re_3_2 0 s3 x16_re_a2 0 -8.121497112006817e+19
Gr16_im_3_2 0 s3 x16_im_a2 0 -4.060615560984281e+19
Gr17_re_3_2 0 s3 x17_re_a2 0 3.182982447509336e+19
Gr17_im_3_2 0 s3 x17_im_a2 0 6.063394571276143e+19
Gr18_re_3_2 0 s3 x18_re_a2 0 -1.98276014676634e+19
Gr18_im_3_2 0 s3 x18_im_a2 0 1.342340259040743e+18
Gr19_re_3_2 0 s3 x19_re_a2 0 9.039526433279823e+19
Gr19_im_3_2 0 s3 x19_im_a2 0 5.090802672281402e+19
Gr20_re_3_2 0 s3 x20_re_a2 0 -2.02261383461321e+18
Gr20_im_3_2 0 s3 x20_im_a2 0 6.093890597944181e+16
Gr21_re_3_2 0 s3 x21_re_a2 0 8.320452812915971e+19
Gr21_im_3_2 0 s3 x21_im_a2 0 -1.150373329947135e+19
Gr22_re_3_2 0 s3 x22_re_a2 0 -2.6531006664196653e+19
Gr22_im_3_2 0 s3 x22_im_a2 0 -1.6757486921110655e+19
Gr23_re_3_2 0 s3 x23_re_a2 0 3.1163579245242753e+19
Gr23_im_3_2 0 s3 x23_im_a2 0 -3.115428099289044e+19
Gr24_re_3_2 0 s3 x24_re_a2 0 -5.658421186677022e+19
Gr24_im_3_2 0 s3 x24_im_a2 0 -1.8427837005194447e+18
Gr25_re_3_2 0 s3 x25_re_a2 0 -1.8229531552253102e+18
Gr25_im_3_2 0 s3 x25_im_a2 0 -2.0572662809428312e+19
Gr26_re_3_2 0 s3 x26_re_a2 0 -8.887780801819777e+19
Gr26_im_3_2 0 s3 x26_im_a2 0 -3.3145437398098694e+19
Gr27_re_3_2 0 s3 x27_re_a2 0 -6.472914094803089e+18
Gr27_im_3_2 0 s3 x27_im_a2 0 -4.309664603109929e+18
Gr28_re_3_2 0 s3 x28_re_a2 0 -1.4644163408816237e+19
Gr28_im_3_2 0 s3 x28_im_a2 0 2.028311205200711e+19
Gr29_re_3_2 0 s3 x29_re_a2 0 -4.4352480631487906e+19
Gr29_im_3_2 0 s3 x29_im_a2 0 -3.5537323575645995e+19
Gr30_re_3_2 0 s3 x30_re_a2 0 -1.9519240889986572e+19
Gr30_im_3_2 0 s3 x30_im_a2 0 1.0153294203647119e+20
Gr31_re_3_2 0 s3 x31_re_a2 0 4.5766027514856505e+19
Gr31_im_3_2 0 s3 x31_im_a2 0 1.462561636246604e+19
Gr32_re_3_2 0 s3 x32_re_a2 0 1.9473215473120104e+19
Gr32_im_3_2 0 s3 x32_im_a2 0 -1.2160096510773582e+19
Gr33_re_3_2 0 s3 x33_re_a2 0 3.5530921252614943e+19
Gr33_im_3_2 0 s3 x33_im_a2 0 2.7181028953104814e+19
Gr34_re_3_2 0 s3 x34_re_a2 0 5.502453089739078e+19
Gr34_im_3_2 0 s3 x34_im_a2 0 1.3626793143211178e+19
Gr35_re_3_2 0 s3 x35_re_a2 0 2.2633455884021748e+19
Gr35_im_3_2 0 s3 x35_im_a2 0 2.820401931212e+19
Gr36_re_3_2 0 s3 x36_re_a2 0 5.823660615613308e+17
Gr36_im_3_2 0 s3 x36_im_a2 0 -1.1767256709125935e+19
Gr37_re_3_2 0 s3 x37_re_a2 0 -1.305458652046349e+20
Gr37_im_3_2 0 s3 x37_im_a2 0 -1.0412416201354366e+20
Gr38_re_3_2 0 s3 x38_re_a2 0 4.5296620605889544e+19
Gr38_im_3_2 0 s3 x38_im_a2 0 2.432912236328911e+19
Gr39_re_3_2 0 s3 x39_re_a2 0 6.834167519080581e+18
Gr39_im_3_2 0 s3 x39_im_a2 0 2.4169008064938254e+19
Gr40_re_3_2 0 s3 x40_re_a2 0 6.241763052123971e+18
Gr40_im_3_2 0 s3 x40_im_a2 0 -4.5971573745312965e+19
Gr41_re_3_2 0 s3 x41_re_a2 0 -1.9193794928964846e+19
Gr41_im_3_2 0 s3 x41_im_a2 0 3.2427272309747106e+19
Gr42_re_3_2 0 s3 x42_re_a2 0 1.2782250314937463e+19
Gr42_im_3_2 0 s3 x42_im_a2 0 -1.4356678130219653e+19
Gr43_re_3_2 0 s3 x43_re_a2 0 -3.720053309250383e+19
Gr43_im_3_2 0 s3 x43_im_a2 0 -3.816833853289583e+18
Gr44_re_3_2 0 s3 x44_re_a2 0 -1.850307208664843e+19
Gr44_im_3_2 0 s3 x44_im_a2 0 2.154920976079788e+19
Gr45_re_3_2 0 s3 x45_re_a2 0 -3.6425519548281197e+19
Gr45_im_3_2 0 s3 x45_im_a2 0 8.529841313225738e+17
Gr46_re_3_2 0 s3 x46_re_a2 0 3.7251833682395e+19
Gr46_im_3_2 0 s3 x46_im_a2 0 2.400946181226552e+19
Gr47_re_3_2 0 s3 x47_re_a2 0 -3.031202944872278e+19
Gr47_im_3_2 0 s3 x47_im_a2 0 1.570899792089295e+19
Gr48_re_3_2 0 s3 x48_re_a2 0 -1.8013783722833127e+19
Gr48_im_3_2 0 s3 x48_im_a2 0 1.4487847019919462e+18
Gr49_re_3_2 0 s3 x49_re_a2 0 -1.0744573003995918e+19
Gr49_im_3_2 0 s3 x49_im_a2 0 -4.431772937070743e+18
Gr50_re_3_2 0 s3 x50_re_a2 0 4.998775189598161e+18
Gr50_im_3_2 0 s3 x50_im_a2 0 -3.1695761918577833e+18
Gr51_re_3_2 0 s3 x51_re_a2 0 1.499625029742773e+19
Gr51_im_3_2 0 s3 x51_im_a2 0 -1.5659560853063747e+18
Gr52_re_3_2 0 s3 x52_re_a2 0 1.674768113285112e+19
Gr52_im_3_2 0 s3 x52_im_a2 0 -1.2307750184756355e+18
Gr53_re_3_2 0 s3 x53_re_a2 0 2.0277947258836185e+19
Gr53_im_3_2 0 s3 x53_im_a2 0 -6.364327674950414e+17
Gr54_re_3_2 0 s3 x54_re_a2 0 2.16474463020538e+19
Gr54_im_3_2 0 s3 x54_im_a2 0 -4.440232136101983e+17
Gr55_re_3_2 0 s3 x55_re_a2 0 2.2310104897284657e+19
Gr55_im_3_2 0 s3 x55_im_a2 0 -2.7491214405733008e+17
Gr56_re_3_2 0 s3 x56_re_a2 0 2.085263697488318e+19
Gr56_im_3_2 0 s3 x56_im_a2 0 -1.519430048571122e+17
Gr57_re_3_2 0 s3 x57_re_a2 0 6.809318994455677e+18
Gr57_im_3_2 0 s3 x57_im_a2 0 -2.61413925906812e+16
Gr58_re_3_2 0 s3 x58_re_a2 0 1.5522963785313298e+19
Gr58_im_3_2 0 s3 x58_im_a2 0 -7.144963823037796e+16
Gr59_re_3_2 0 s3 x59_re_a2 0 3.623724206799863e+16
Gr59_im_3_2 0 s3 x59_im_a2 0 -548362312190911.06
Gr60_re_3_2 0 s3 x60_re_a2 0 1.1476064041234833e+18
Gr60_im_3_2 0 s3 x60_im_a2 0 -6041703224245088.0
Gd3_3 0 s3 p3 0 0.0016625159028860696
Fd3_3 0 s3 V3 0.08312579514430347
Gr1_re_3_3 0 s3 x1_re_a3 0 16200645658.252752
Gr1_im_3_3 0 s3 x1_im_a3 0 -16011618279.824625
Gr2_re_3_3 0 s3 x2_re_a3 0 2595894134786776.0
Gr2_im_3_3 0 s3 x2_im_a3 0 -1602313118816567.2
Gr3_re_3_3 0 s3 x3_re_a3 0 -2.5733748675430884e+16
Gr3_im_3_3 0 s3 x3_im_a3 0 -2.5786806346341944e+16
Gr4_re_3_3 0 s3 x4_re_a3 0 3.090852655198296e+16
Gr4_im_3_3 0 s3 x4_im_a3 0 9.879242832600597e+16
Gr5_re_3_3 0 s3 x5_re_a3 0 4.5336845374775386e+17
Gr5_im_3_3 0 s3 x5_im_a3 0 -3.188907307238919e+16
Gr6_re_3_3 0 s3 x6_re_a3 0 -9198588109932246.0
Gr6_im_3_3 0 s3 x6_im_a3 0 4.695577570619502e+17
Gr7_re_3_3 0 s3 x7_re_a3 0 5.44481390192692e+17
Gr7_im_3_3 0 s3 x7_im_a3 0 -1.1239070109300297e+18
Gr8_re_3_3 0 s3 x8_re_a3 0 1.0934117799210281e+18
Gr8_im_3_3 0 s3 x8_im_a3 0 -8.490664777105004e+17
Gr9_re_3_3 0 s3 x9_re_a3 0 -2.688311194103688e+18
Gr9_im_3_3 0 s3 x9_im_a3 0 -3.6396514985547795e+17
Gr10_re_3_3 0 s3 x10_re_a3 0 -3.212765680604784e+19
Gr10_im_3_3 0 s3 x10_im_a3 0 -1.2762498937294758e+19
Gr11_re_3_3 0 s3 x11_re_a3 0 -1.170442115046716e+19
Gr11_im_3_3 0 s3 x11_im_a3 0 2.206410766749918e+19
Gr12_re_3_3 0 s3 x12_re_a3 0 9.937833164022625e+19
Gr12_im_3_3 0 s3 x12_im_a3 0 8.046395738568189e+18
Gr13_re_3_3 0 s3 x13_re_a3 0 -2.4560386425261162e+19
Gr13_im_3_3 0 s3 x13_im_a3 0 -2.0122663752573407e+19
Gr14_re_3_3 0 s3 x14_re_a3 0 -1.4952942947250854e+19
Gr14_im_3_3 0 s3 x14_im_a3 0 4.930854033108119e+18
Gr15_re_3_3 0 s3 x15_re_a3 0 -1.8830817185429946e+19
Gr15_im_3_3 0 s3 x15_im_a3 0 -1.565397304258951e+19
Gr16_re_3_3 0 s3 x16_re_a3 0 -5.519733052505146e+19
Gr16_im_3_3 0 s3 x16_im_a3 0 -3.1780789161285165e+19
Gr17_re_3_3 0 s3 x17_re_a3 0 2.1059220573421847e+19
Gr17_im_3_3 0 s3 x17_im_a3 0 4.249942492043148e+19
Gr18_re_3_3 0 s3 x18_re_a3 0 -1.4466191582815791e+19
Gr18_im_3_3 0 s3 x18_im_a3 0 -9.977108489938432e+17
Gr19_re_3_3 0 s3 x19_re_a3 0 6.128810535539707e+19
Gr19_im_3_3 0 s3 x19_im_a3 0 3.807069884062873e+19
Gr20_re_3_3 0 s3 x20_re_a3 0 -2.6607160352323446e+18
Gr20_im_3_3 0 s3 x20_im_a3 0 3.5333253431638605e+17
Gr21_re_3_3 0 s3 x21_re_a3 0 5.8433086345096266e+19
Gr21_im_3_3 0 s3 x21_im_a3 0 -5.205092256590404e+18
Gr22_re_3_3 0 s3 x22_re_a3 0 -1.9243972109378216e+19
Gr22_im_3_3 0 s3 x22_im_a3 0 -1.0732744759995666e+19
Gr23_re_3_3 0 s3 x23_re_a3 0 2.317745859256686e+19
Gr23_im_3_3 0 s3 x23_im_a3 0 -2.01426312216327e+19
Gr24_re_3_3 0 s3 x24_re_a3 0 -3.977347691277689e+19
Gr24_im_3_3 0 s3 x24_im_a3 0 -4.954400459935063e+17
Gr25_re_3_3 0 s3 x25_re_a3 0 6.604511528139118e+17
Gr25_im_3_3 0 s3 x25_im_a3 0 -1.4691086629236453e+19
Gr26_re_3_3 0 s3 x26_re_a3 0 -6.140248838823449e+19
Gr26_im_3_3 0 s3 x26_im_a3 0 -2.512796539948118e+19
Gr27_re_3_3 0 s3 x27_re_a3 0 -3.3995831917464156e+18
Gr27_im_3_3 0 s3 x27_im_a3 0 -3.8719012693341507e+18
Gr28_re_3_3 0 s3 x28_re_a3 0 -1.0387801037797902e+19
Gr28_im_3_3 0 s3 x28_im_a3 0 1.413591378226973e+19
Gr29_re_3_3 0 s3 x29_re_a3 0 -2.970420394047354e+19
Gr29_im_3_3 0 s3 x29_im_a3 0 -2.7250614946706444e+19
Gr30_re_3_3 0 s3 x30_re_a3 0 -1.6453827304743641e+19
Gr30_im_3_3 0 s3 x30_im_a3 0 6.7851483351966925e+19
Gr31_re_3_3 0 s3 x31_re_a3 0 3.240037216473964e+19
Gr31_im_3_3 0 s3 x31_im_a3 0 1.1358177606416912e+19
Gr32_re_3_3 0 s3 x32_re_a3 0 1.4008271427962407e+19
Gr32_im_3_3 0 s3 x32_im_a3 0 -1.067468434948821e+19
Gr33_re_3_3 0 s3 x33_re_a3 0 2.367165028902026e+19
Gr33_im_3_3 0 s3 x33_im_a3 0 2.0861492796560515e+19
Gr34_re_3_3 0 s3 x34_re_a3 0 3.886660676618324e+19
Gr34_im_3_3 0 s3 x34_im_a3 0 8.49472319074829e+18
Gr35_re_3_3 0 s3 x35_re_a3 0 1.4453343736637538e+19
Gr35_im_3_3 0 s3 x35_im_a3 0 2.0997320503190794e+19
Gr36_re_3_3 0 s3 x36_re_a3 0 -4.105282201151538e+17
Gr36_im_3_3 0 s3 x36_im_a3 0 -8.308499534540276e+18
Gr37_re_3_3 0 s3 x37_re_a3 0 -8.721362624041096e+19
Gr37_im_3_3 0 s3 x37_im_a3 0 -6.821388918967455e+19
Gr38_re_3_3 0 s3 x38_re_a3 0 3.1421311031546565e+19
Gr38_im_3_3 0 s3 x38_im_a3 0 1.7825841266061531e+19
Gr39_re_3_3 0 s3 x39_re_a3 0 3.00548386412868e+18
Gr39_im_3_3 0 s3 x39_im_a3 0 1.822221461928603e+19
Gr40_re_3_3 0 s3 x40_re_a3 0 4.957229667548463e+18
Gr40_im_3_3 0 s3 x40_im_a3 0 -3.220545038006434e+19
Gr41_re_3_3 0 s3 x41_re_a3 0 -1.099237872907888e+19
Gr41_im_3_3 0 s3 x41_im_a3 0 2.54227784188986e+19
Gr42_re_3_3 0 s3 x42_re_a3 0 7.827027410283844e+18
Gr42_im_3_3 0 s3 x42_im_a3 0 -1.34448973567892e+19
Gr43_re_3_3 0 s3 x43_re_a3 0 -2.6003703058854322e+19
Gr43_im_3_3 0 s3 x43_im_a3 0 -4.711521296861636e+18
Gr44_re_3_3 0 s3 x44_re_a3 0 -1.2847890887772901e+19
Gr44_im_3_3 0 s3 x44_im_a3 0 1.5060193432214163e+19
Gr45_re_3_3 0 s3 x45_re_a3 0 -2.6161090835220775e+19
Gr45_im_3_3 0 s3 x45_im_a3 0 -2.075962980917087e+18
Gr46_re_3_3 0 s3 x46_re_a3 0 2.603902764751507e+19
Gr46_im_3_3 0 s3 x46_im_a3 0 1.5760823325877877e+19
Gr47_re_3_3 0 s3 x47_re_a3 0 -2.1861363545788252e+19
Gr47_im_3_3 0 s3 x47_im_a3 0 9.71890269007011e+18
Gr48_re_3_3 0 s3 x48_re_a3 0 -1.3325384259511796e+19
Gr48_im_3_3 0 s3 x48_im_a3 0 -4.03377902214257e+17
Gr49_re_3_3 0 s3 x49_re_a3 0 -7.985078652146558e+18
Gr49_im_3_3 0 s3 x49_im_a3 0 -4.164488805392397e+18
Gr50_re_3_3 0 s3 x50_re_a3 0 3.3081535787068887e+18
Gr50_im_3_3 0 s3 x50_im_a3 0 -2.7211302276024566e+18
Gr51_re_3_3 0 s3 x51_re_a3 0 1.0442302306742706e+19
Gr51_im_3_3 0 s3 x51_im_a3 0 -1.3294059820147302e+18
Gr52_re_3_3 0 s3 x52_re_a3 0 1.1671749010986525e+19
Gr52_im_3_3 0 s3 x52_im_a3 0 -1.0487665099720741e+18
Gr53_re_3_3 0 s3 x53_re_a3 0 1.4177576590704833e+19
Gr53_im_3_3 0 s3 x53_im_a3 0 -5.435779458114449e+17
Gr54_re_3_3 0 s3 x54_re_a3 0 1.516715980416398e+19
Gr54_im_3_3 0 s3 x54_im_a3 0 -3.780138405506905e+17
Gr55_re_3_3 0 s3 x55_re_a3 0 1.5658828982918105e+19
Gr55_im_3_3 0 s3 x55_im_a3 0 -2.333344971481119e+17
Gr56_re_3_3 0 s3 x56_re_a3 0 1.4653050048674173e+19
Gr56_im_3_3 0 s3 x56_im_a3 0 -1.2873264734781928e+17
Gr57_re_3_3 0 s3 x57_re_a3 0 4.790581327506308e+18
Gr57_im_3_3 0 s3 x57_im_a3 0 -2.2114516160960656e+16
Gr58_re_3_3 0 s3 x58_re_a3 0 1.091587796344423e+19
Gr58_im_3_3 0 s3 x58_im_a3 0 -6.046533660139848e+16
Gr59_re_3_3 0 s3 x59_re_a3 0 2.550504526478696e+16
Gr59_im_3_3 0 s3 x59_im_a3 0 -463274819885123.94
Gr60_re_3_3 0 s3 x60_re_a3 0 8.075751991691808e+17
Gr60_im_3_3 0 s3 x60_im_a3 0 -5110035472013456.0
Gd3_4 0 s3 p4 0 2.0402678158215025e-06
Fd3_4 0 s3 V4 0.00010201339079107513
Gr1_re_3_4 0 s3 x1_re_a4 0 -7287364806.2149515
Gr1_im_3_4 0 s3 x1_im_a4 0 8077670466.833807
Gr2_re_3_4 0 s3 x2_re_a4 0 -1224029234280018.8
Gr2_im_3_4 0 s3 x2_im_a4 0 844745242461268.1
Gr3_re_3_4 0 s3 x3_re_a4 0 1.3164287290225348e+16
Gr3_im_3_4 0 s3 x3_im_a4 0 1.1938642222063494e+16
Gr4_re_3_4 0 s3 x4_re_a4 0 -1.7402993992773708e+16
Gr4_im_3_4 0 s3 x4_im_a4 0 -4.7434113353403864e+16
Gr5_re_3_4 0 s3 x5_re_a4 0 -2.2244252960713706e+17
Gr5_im_3_4 0 s3 x5_im_a4 0 2.595712370573252e+16
Gr6_re_3_4 0 s3 x6_re_a4 0 -5728403252235118.0
Gr6_im_3_4 0 s3 x6_im_a4 0 -2.294785955791759e+17
Gr7_re_3_4 0 s3 x7_re_a4 0 -2.422793863853051e+17
Gr7_im_3_4 0 s3 x7_im_a4 0 5.606545598852885e+17
Gr8_re_3_4 0 s3 x8_re_a4 0 -5.187991774362742e+17
Gr8_im_3_4 0 s3 x8_im_a4 0 4.3640512577424256e+17
Gr9_re_3_4 0 s3 x9_re_a4 0 1.3236673986614769e+18
Gr9_im_3_4 0 s3 x9_im_a4 0 1.3100661528536488e+17
Gr10_re_3_4 0 s3 x10_re_a4 0 1.5961685423681593e+19
Gr10_im_3_4 0 s3 x10_im_a4 0 5.796483055358051e+18
Gr11_re_3_4 0 s3 x11_re_a4 0 5.45017589532524e+18
Gr11_im_3_4 0 s3 x11_im_a4 0 -1.0998587009454879e+19
Gr12_re_3_4 0 s3 x12_re_a4 0 -4.899753813004014e+19
Gr12_im_3_4 0 s3 x12_im_a4 0 -2.771710844280874e+18
Gr13_re_3_4 0 s3 x13_re_a4 0 1.2260835645643039e+19
Gr13_im_3_4 0 s3 x13_im_a4 0 9.712663519646138e+18
Gr14_re_3_4 0 s3 x14_re_a4 0 7.376176869796313e+18
Gr14_im_3_4 0 s3 x14_im_a4 0 -2.0644198635316652e+18
Gr15_re_3_4 0 s3 x15_re_a4 0 9.510559199519285e+18
Gr15_im_3_4 0 s3 x15_im_a4 0 7.098214743172782e+18
Gr16_re_3_4 0 s3 x16_re_a4 0 2.7471384082602754e+19
Gr16_im_3_4 0 s3 x16_im_a4 0 1.5027293133690071e+19
Gr17_re_3_4 0 s3 x17_re_a4 0 -1.0591361060337445e+19
Gr17_im_3_4 0 s3 x17_im_a4 0 -2.0909705446225932e+19
Gr18_re_3_4 0 s3 x18_re_a4 0 7.011417711291444e+18
Gr18_im_3_4 0 s3 x18_im_a4 0 1.3668784675908992e+17
Gr19_re_3_4 0 s3 x19_re_a4 0 -3.053299002049433e+19
Gr19_im_3_4 0 s3 x19_im_a4 0 -1.8292146540158284e+19
Gr20_re_3_4 0 s3 x20_re_a4 0 1.0819393233535827e+18
Gr20_im_3_4 0 s3 x20_im_a4 0 -1.1550669688968667e+17
Gr21_re_3_4 0 s3 x21_re_a4 0 -2.872748857761869e+19
Gr21_im_3_4 0 s3 x21_im_a4 0 3.084809337778728e+18
Gr22_re_3_4 0 s3 x22_re_a4 0 9.351459987564904e+18
Gr22_im_3_4 0 s3 x22_im_a4 0 5.467105049356962e+18
Gr23_re_3_4 0 s3 x23_re_a4 0 -1.1157948511285285e+19
Gr23_im_3_4 0 s3 x23_im_a4 0 1.022002018618227e+19
Gr24_re_3_4 0 s3 x24_re_a4 0 1.9550535709696905e+19
Gr24_im_3_4 0 s3 x24_im_a4 0 3.895522790230058e+17
Gr25_re_3_4 0 s3 x25_re_a4 0 2.9943375654074496e+16
Gr25_im_3_4 0 s3 x25_im_a4 0 7.176989729946031e+18
Gr26_re_3_4 0 s3 x26_re_a4 0 3.0374813738125844e+19
Gr26_im_3_4 0 s3 x26_im_a4 0 1.201552806599326e+19
Gr27_re_3_4 0 s3 x27_re_a4 0 1.8803896117466537e+18
Gr27_im_3_4 0 s3 x27_im_a4 0 1.7481100537886574e+18
Gr28_re_3_4 0 s3 x28_re_a4 0 5.088504659035734e+18
Gr28_im_3_4 0 s3 x28_im_a4 0 -6.970260222022672e+18
Gr29_re_3_4 0 s3 x29_re_a4 0 1.4867378955166882e+19
Gr29_im_3_4 0 s3 x29_im_a4 0 1.2977958741576514e+19
Gr30_re_3_4 0 s3 x30_re_a4 0 7.584791804302553e+18
Gr30_im_3_4 0 s3 x30_im_a4 0 -3.3991298621727162e+19
Gr31_re_3_4 0 s3 x31_re_a4 0 -1.58825667801107e+19
Gr31_im_3_4 0 s3 x31_im_a4 0 -5.385996438472507e+18
Gr32_re_3_4 0 s3 x32_re_a4 0 -6.828465842492599e+18
Gr32_im_3_4 0 s3 x32_im_a4 0 4.857804345446918e+18
Gr33_re_3_4 0 s3 x33_re_a4 0 -1.187221101677014e+19
Gr33_im_3_4 0 s3 x33_im_a4 0 -9.932032747114916e+18
Gr34_re_3_4 0 s3 x34_re_a4 0 -1.9070029204679655e+19
Gr34_im_3_4 0 s3 x34_im_a4 0 -4.3735603335929293e+18
Gr35_re_3_4 0 s3 x35_re_a4 0 -7.369619878907715e+18
Gr35_im_3_4 0 s3 x35_im_a4 0 -1.0105421434281978e+19
Gr36_re_3_4 0 s3 x36_re_a4 0 5.186603927786932e+16
Gr36_im_3_4 0 s3 x36_im_a4 0 4.077536033640936e+18
Gr37_re_3_4 0 s3 x37_re_a4 0 4.370235133902089e+19
Gr37_im_3_4 0 s3 x37_im_a4 0 3.443702746524012e+19
Gr38_re_3_4 0 s3 x38_re_a4 0 -1.5520404168830165e+19
Gr38_im_3_4 0 s3 x38_im_a4 0 -8.629064229185918e+18
Gr39_re_3_4 0 s3 x39_re_a4 0 -1.8053531181279224e+18
Gr39_im_3_4 0 s3 x39_im_a4 0 -8.730142735345213e+18
Gr40_re_3_4 0 s3 x40_re_a4 0 -2.3323528201620255e+18
Gr40_im_3_4 0 s3 x40_im_a4 0 1.584928945295075e+19
Gr41_re_3_4 0 s3 x41_re_a4 0 5.860955253399871e+18
Gr41_im_3_4 0 s3 x41_im_a4 0 -1.2015930947513983e+19
Gr42_re_3_4 0 s3 x42_re_a4 0 -4.059957755134505e+18
Gr42_im_3_4 0 s3 x42_im_a4 0 5.995575190232279e+18
Gr43_re_3_4 0 s3 x43_re_a4 0 1.2807547357349755e+19
Gr43_im_3_4 0 s3 x43_im_a4 0 1.9447738975206374e+18
Gr44_re_3_4 0 s3 x44_re_a4 0 6.343959591870591e+18
Gr44_im_3_4 0 s3 x44_im_a4 0 -7.41839320296867e+18
Gr45_re_3_4 0 s3 x45_re_a4 0 1.2756536794425856e+19
Gr45_im_3_4 0 s3 x45_im_a4 0 5.3110453468800134e+17
Gr46_re_3_4 0 s3 x46_re_a4 0 -1.2825615079604754e+19
Gr46_im_3_4 0 s3 x46_im_a4 0 -7.950893725158875e+18
Gr47_re_3_4 0 s3 x47_re_a4 0 1.064388764461811e+19
Gr47_im_3_4 0 s3 x47_im_a4 0 -5.019036043104897e+18
Gr48_re_3_4 0 s3 x48_re_a4 0 6.428360982195228e+18
Gr48_im_3_4 0 s3 x48_im_a4 0 -6.1746671079692744e+16
Gr49_re_3_4 0 s3 x49_re_a4 0 3.845666355812805e+18
Gr49_im_3_4 0 s3 x49_im_a4 0 1.8550267408565632e+18
Gr50_re_3_4 0 s3 x50_re_a4 0 -1.6636784872954435e+18
Gr50_im_3_4 0 s3 x50_im_a4 0 1.2472937247093832e+18
Gr51_re_3_4 0 s3 x51_re_a4 0 -5.150730344815095e+18
Gr51_im_3_4 0 s3 x51_im_a4 0 6.116089742574574e+17
Gr52_re_3_4 0 s3 x52_re_a4 0 -5.755332409609844e+18
Gr52_im_3_4 0 s3 x52_im_a4 0 4.8190531142404275e+17
Gr53_re_3_4 0 s3 x53_re_a4 0 -6.982539665116569e+18
Gr53_im_3_4 0 s3 x53_im_a4 0 2.4958224214734426e+17
Gr54_re_3_4 0 s3 x54_re_a4 0 -7.464010961326138e+18
Gr54_im_3_4 0 s3 x54_im_a4 0 1.7374860820023363e+17
Gr55_re_3_4 0 s3 x55_re_a4 0 -7.700940566161023e+18
Gr55_im_3_4 0 s3 x55_im_a4 0 1.07355831088372e+17
Gr56_re_3_4 0 s3 x56_re_a4 0 -7.203153393571972e+18
Gr56_im_3_4 0 s3 x56_im_a4 0 5.926404683774452e+16
Gr57_re_3_4 0 s3 x57_re_a4 0 -2.3539111612018785e+18
Gr57_im_3_4 0 s3 x57_im_a4 0 1.0185854008055816e+16
Gr58_re_3_4 0 s3 x58_re_a4 0 -5.364573263328584e+18
Gr58_im_3_4 0 s3 x58_im_a4 0 2.784674344004723e+16
Gr59_re_3_4 0 s3 x59_re_a4 0 -1.2530214933457806e+16
Gr59_im_3_4 0 s3 x59_im_a4 0 213476050783208.2
Gr60_re_3_4 0 s3 x60_re_a4 0 -3.96776118859203e+17
Gr60_im_3_4 0 s3 x60_im_a4 0 2353811584430139.0
*
* State networks driven by port 3
Cx1_re_a3 x1_re_a3 0 1.0
Gx1_re_a3 0 x1_re_a3 p3 0 0.1414213562373095
Fx1_re_a3 0 x1_re_a3 V3 7.0710678118654755
Rp1_re_re_a3 0 x1_re_a3 1.9339271087549648e-10
Gp1_re_im_a3 0 x1_re_a3 x1_im_a3 0 347079283315.0595
Cx1_im_a3 x1_im_a3 0 1.0
Gp1_im_re_a3 0 x1_im_a3 x1_re_a3 0 -347079283315.0595
Rp1_im_im_a3 0 x1_im_a3 1.9339271087549648e-10
Cx2_re_a3 x2_re_a3 0 1.0
Gx2_re_a3 0 x2_re_a3 p3 0 0.1414213562373095
Fx2_re_a3 0 x2_re_a3 V3 7.0710678118654755
Rp2_re_re_a3 0 x2_re_a3 5.691004706881973e-10
Gp2_re_im_a3 0 x2_re_a3 x2_im_a3 0 303418375537.5658
Cx2_im_a3 x2_im_a3 0 1.0
Gp2_im_re_a3 0 x2_im_a3 x2_re_a3 0 -303418375537.5658
Rp2_im_im_a3 0 x2_im_a3 5.691004706881973e-10
Cx3_re_a3 x3_re_a3 0 1.0
Gx3_re_a3 0 x3_re_a3 p3 0 0.1414213562373095
Fx3_re_a3 0 x3_re_a3 V3 7.0710678118654755
Rp3_re_re_a3 0 x3_re_a3 5.362465275255059e-10
Gp3_re_im_a3 0 x3_re_a3 x3_im_a3 0 299764945822.76807
Cx3_im_a3 x3_im_a3 0 1.0
Gp3_im_re_a3 0 x3_im_a3 x3_re_a3 0 -299764945822.76807
Rp3_im_im_a3 0 x3_im_a3 5.362465275255059e-10
Cx4_re_a3 x4_re_a3 0 1.0
Gx4_re_a3 0 x4_re_a3 p3 0 0.1414213562373095
Fx4_re_a3 0 x4_re_a3 V3 7.0710678118654755
Rp4_re_re_a3 0 x4_re_a3 5.651020630265948e-10
Gp4_re_im_a3 0 x4_re_a3 x4_im_a3 0 295780770455.4801
Cx4_im_a3 x4_im_a3 0 1.0
Gp4_im_re_a3 0 x4_im_a3 x4_re_a3 0 -295780770455.4801
Rp4_im_im_a3 0 x4_im_a3 5.651020630265948e-10
Cx5_re_a3 x5_re_a3 0 1.0
Gx5_re_a3 0 x5_re_a3 p3 0 0.1414213562373095
Fx5_re_a3 0 x5_re_a3 V3 7.0710678118654755
Rp5_re_re_a3 0 x5_re_a3 4.4583648371353355e-11
Gp5_re_im_a3 0 x5_re_a3 x5_im_a3 0 280184551048.1205
Cx5_im_a3 x5_im_a3 0 1.0
Gp5_im_re_a3 0 x5_im_a3 x5_re_a3 0 -280184551048.1205
Rp5_im_im_a3 0 x5_im_a3 4.4583648371353355e-11
Cx6_re_a3 x6_re_a3 0 1.0
Gx6_re_a3 0 x6_re_a3 p3 0 0.1414213562373095
Fx6_re_a3 0 x6_re_a3 V3 7.0710678118654755
Rp6_re_re_a3 0 x6_re_a3 9.027710283976132e-10
Gp6_re_im_a3 0 x6_re_a3 x6_im_a3 0 284797609898.4314
Cx6_im_a3 x6_im_a3 0 1.0
Gp6_im_re_a3 0 x6_im_a3 x6_re_a3 0 -284797609898.4314
Rp6_im_im_a3 0 x6_im_a3 9.027710283976132e-10
Cx7_re_a3 x7_re_a3 0 1.0
Gx7_re_a3 0 x7_re_a3 p3 0 0.1414213562373095
Fx7_re_a3 0 x7_re_a3 V3 7.0710678118654755
Rp7_re_re_a3 0 x7_re_a3 7.771258315741444e-10
Gp7_re_im_a3 0 x7_re_a3 x7_im_a3 0 280937443543.525
Cx7_im_a3 x7_im_a3 0 1.0
Gp7_im_re_a3 0 x7_im_a3 x7_re_a3 0 -280937443543.525
Rp7_im_im_a3 0 x7_im_a3 7.771258315741444e-10
Cx8_re_a3 x8_re_a3 0 1.0
Gx8_re_a3 0 x8_re_a3 p3 0 0.1414213562373095
Fx8_re_a3 0 x8_re_a3 V3 7.0710678118654755
Rp8_re_re_a3 0 x8_re_a3 1.3252660304487296e-09
Gp8_re_im_a3 0 x8_re_a3 x8_im_a3 0 269390760843.16248
Cx8_im_a3 x8_im_a3 0 1.0
Gp8_im_re_a3 0 x8_im_a3 x8_re_a3 0 -269390760843.16248
Rp8_im_im_a3 0 x8_im_a3 1.3252660304487296e-09
Cx9_re_a3 x9_re_a3 0 1.0
Gx9_re_a3 0 x9_re_a3 p3 0 0.1414213562373095
Fx9_re_a3 0 x9_re_a3 V3 7.0710678118654755
Rp9_re_re_a3 0 x9_re_a3 8.837487410164448e-10
Gp9_re_im_a3 0 x9_re_a3 x9_im_a3 0 260736146261.56058
Cx9_im_a3 x9_im_a3 0 1.0
Gp9_im_re_a3 0 x9_im_a3 x9_re_a3 0 -260736146261.56058
Rp9_im_im_a3 0 x9_im_a3 8.837487410164448e-10
Cx10_re_a3 x10_re_a3 0 1.0
Gx10_re_a3 0 x10_re_a3 p3 0 0.1414213562373095
Fx10_re_a3 0 x10_re_a3 V3 7.0710678118654755
Rp10_re_re_a3 0 x10_re_a3 7.74337520639369e-10
Gp10_re_im_a3 0 x10_re_a3 x10_im_a3 0 246291422182.96008
Cx10_im_a3 x10_im_a3 0 1.0
Gp10_im_re_a3 0 x10_im_a3 x10_re_a3 0 -246291422182.96008
Rp10_im_im_a3 0 x10_im_a3 7.74337520639369e-10
Cx11_re_a3 x11_re_a3 0 1.0
Gx11_re_a3 0 x11_re_a3 p3 0 0.1414213562373095
Fx11_re_a3 0 x11_re_a3 V3 7.0710678118654755
Rp11_re_re_a3 0 x11_re_a3 8.390860458298588e-10
Gp11_re_im_a3 0 x11_re_a3 x11_im_a3 0 242228737451.13144
Cx11_im_a3 x11_im_a3 0 1.0
Gp11_im_re_a3 0 x11_im_a3 x11_re_a3 0 -242228737451.13144
Rp11_im_im_a3 0 x11_im_a3 8.390860458298588e-10
Cx12_re_a3 x12_re_a3 0 1.0
Gx12_re_a3 0 x12_re_a3 p3 0 0.1414213562373095
Fx12_re_a3 0 x12_re_a3 V3 7.0710678118654755
Rp12_re_re_a3 0 x12_re_a3 4.4656692854153325e-10
Gp12_re_im_a3 0 x12_re_a3 x12_im_a3 0 236640156802.20322
Cx12_im_a3 x12_im_a3 0 1.0
Gp12_im_re_a3 0 x12_im_a3 x12_re_a3 0 -236640156802.20322
Rp12_im_im_a3 0 x12_im_a3 4.4656692854153325e-10
Cx13_re_a3 x13_re_a3 0 1.0
Gx13_re_a3 0 x13_re_a3 p3 0 0.1414213562373095
Fx13_re_a3 0 x13_re_a3 V3 7.0710678118654755
Rp13_re_re_a3 0 x13_re_a3 6.602787100602715e-10
Gp13_re_im_a3 0 x13_re_a3 x13_im_a3 0 229310531843.11926
Cx13_im_a3 x13_im_a3 0 1.0
Gp13_im_re_a3 0 x13_im_a3 x13_re_a3 0 -229310531843.11926
Rp13_im_im_a3 0 x13_im_a3 6.602787100602715e-10
Cx14_re_a3 x14_re_a3 0 1.0
Gx14_re_a3 0 x14_re_a3 p3 0 0.1414213562373095
Fx14_re_a3 0 x14_re_a3 V3 7.0710678118654755
Rp14_re_re_a3 0 x14_re_a3 6.683832237932593e-10
Gp14_re_im_a3 0 x14_re_a3 x14_im_a3 0 221343536942.1764
Cx14_im_a3 x14_im_a3 0 1.0
Gp14_im_re_a3 0 x14_im_a3 x14_re_a3 0 -221343536942.1764
Rp14_im_im_a3 0 x14_im_a3 6.683832237932593e-10
Cx15_re_a3 x15_re_a3 0 1.0
Gx15_re_a3 0 x15_re_a3 p3 0 0.1414213562373095
Fx15_re_a3 0 x15_re_a3 V3 7.0710678118654755
Rp15_re_re_a3 0 x15_re_a3 7.821256797324849e-10
Gp15_re_im_a3 0 x15_re_a3 x15_im_a3 0 216900169045.56696
Cx15_im_a3 x15_im_a3 0 1.0
Gp15_im_re_a3 0 x15_im_a3 x15_re_a3 0 -216900169045.56696
Rp15_im_im_a3 0 x15_im_a3 7.821256797324849e-10
Cx16_re_a3 x16_re_a3 0 1.0
Gx16_re_a3 0 x16_re_a3 p3 0 0.1414213562373095
Fx16_re_a3 0 x16_re_a3 V3 7.0710678118654755
Rp16_re_re_a3 0 x16_re_a3 7.830440984431804e-10
Gp16_re_im_a3 0 x16_re_a3 x16_im_a3 0 205989675376.3724
Cx16_im_a3 x16_im_a3 0 1.0
Gp16_im_re_a3 0 x16_im_a3 x16_re_a3 0 -205989675376.3724
Rp16_im_im_a3 0 x16_im_a3 7.830440984431804e-10
Cx17_re_a3 x17_re_a3 0 1.0
Gx17_re_a3 0 x17_re_a3 p3 0 0.1414213562373095
Fx17_re_a3 0 x17_re_a3 V3 7.0710678118654755
Rp17_re_re_a3 0 x17_re_a3 3.6596596885047425e-10
Gp17_re_im_a3 0 x17_re_a3 x17_im_a3 0 200356736984.54144
Cx17_im_a3 x17_im_a3 0 1.0
Gp17_im_re_a3 0 x17_im_a3 x17_re_a3 0 -200356736984.54144
Rp17_im_im_a3 0 x17_im_a3 3.6596596885047425e-10
Cx18_re_a3 x18_re_a3 0 1.0
Gx18_re_a3 0 x18_re_a3 p3 0 0.1414213562373095
Fx18_re_a3 0 x18_re_a3 V3 7.0710678118654755
Rp18_re_re_a3 0 x18_re_a3 4.584479098871507e-10
Gp18_re_im_a3 0 x18_re_a3 x18_im_a3 0 194828352286.79108
Cx18_im_a3 x18_im_a3 0 1.0
Gp18_im_re_a3 0 x18_im_a3 x18_re_a3 0 -194828352286.79108
Rp18_im_im_a3 0 x18_im_a3 4.584479098871507e-10
Cx19_re_a3 x19_re_a3 0 1.0
Gx19_re_a3 0 x19_re_a3 p3 0 0.1414213562373095
Fx19_re_a3 0 x19_re_a3 V3 7.0710678118654755
Rp19_re_re_a3 0 x19_re_a3 3.2577500493070084e-10
Gp19_re_im_a3 0 x19_re_a3 x19_im_a3 0 187933840477.96106
Cx19_im_a3 x19_im_a3 0 1.0
Gp19_im_re_a3 0 x19_im_a3 x19_re_a3 0 -187933840477.96106
Rp19_im_im_a3 0 x19_im_a3 3.2577500493070084e-10
Cx20_re_a3 x20_re_a3 0 1.0
Gx20_re_a3 0 x20_re_a3 p3 0 0.1414213562373095
Fx20_re_a3 0 x20_re_a3 V3 7.0710678118654755
Rp20_re_re_a3 0 x20_re_a3 3.7030670747264964e-10
Gp20_re_im_a3 0 x20_re_a3 x20_im_a3 0 182988642847.68027
Cx20_im_a3 x20_im_a3 0 1.0
Gp20_im_re_a3 0 x20_im_a3 x20_re_a3 0 -182988642847.68027
Rp20_im_im_a3 0 x20_im_a3 3.7030670747264964e-10
Cx21_re_a3 x21_re_a3 0 1.0
Gx21_re_a3 0 x21_re_a3 p3 0 0.1414213562373095
Fx21_re_a3 0 x21_re_a3 V3 7.0710678118654755
Rp21_re_re_a3 0 x21_re_a3 4.088062182753204e-10
Gp21_re_im_a3 0 x21_re_a3 x21_im_a3 0 177633712933.48953
Cx21_im_a3 x21_im_a3 0 1.0
Gp21_im_re_a3 0 x21_im_a3 x21_re_a3 0 -177633712933.48953
Rp21_im_im_a3 0 x21_im_a3 4.088062182753204e-10
Cx22_re_a3 x22_re_a3 0 1.0
Gx22_re_a3 0 x22_re_a3 p3 0 0.1414213562373095
Fx22_re_a3 0 x22_re_a3 V3 7.0710678118654755
Rp22_re_re_a3 0 x22_re_a3 3.9909194915050626e-10
Gp22_re_im_a3 0 x22_re_a3 x22_im_a3 0 170516011194.32175
Cx22_im_a3 x22_im_a3 0 1.0
Gp22_im_re_a3 0 x22_im_a3 x22_re_a3 0 -170516011194.32175
Rp22_im_im_a3 0 x22_im_a3 3.9909194915050626e-10
Cx23_re_a3 x23_re_a3 0 1.0
Gx23_re_a3 0 x23_re_a3 p3 0 0.1414213562373095
Fx23_re_a3 0 x23_re_a3 V3 7.0710678118654755
Rp23_re_re_a3 0 x23_re_a3 3.5380163711038947e-10
Gp23_re_im_a3 0 x23_re_a3 x23_im_a3 0 164953816321.0323
Cx23_im_a3 x23_im_a3 0 1.0
Gp23_im_re_a3 0 x23_im_a3 x23_re_a3 0 -164953816321.0323
Rp23_im_im_a3 0 x23_im_a3 3.5380163711038947e-10
Cx24_re_a3 x24_re_a3 0 1.0
Gx24_re_a3 0 x24_re_a3 p3 0 0.1414213562373095
Fx24_re_a3 0 x24_re_a3 V3 7.0710678118654755
Rp24_re_re_a3 0 x24_re_a3 5.039130565519937e-10
Gp24_re_im_a3 0 x24_re_a3 x24_im_a3 0 159173864190.63727
Cx24_im_a3 x24_im_a3 0 1.0
Gp24_im_re_a3 0 x24_im_a3 x24_re_a3 0 -159173864190.63727
Rp24_im_im_a3 0 x24_im_a3 5.039130565519937e-10
Cx25_re_a3 x25_re_a3 0 1.0
Gx25_re_a3 0 x25_re_a3 p3 0 0.1414213562373095
Fx25_re_a3 0 x25_re_a3 V3 7.0710678118654755
Rp25_re_re_a3 0 x25_re_a3 4.289339569151169e-10
Gp25_re_im_a3 0 x25_re_a3 x25_im_a3 0 152473894102.3021
Cx25_im_a3 x25_im_a3 0 1.0
Gp25_im_re_a3 0 x25_im_a3 x25_re_a3 0 -152473894102.3021
Rp25_im_im_a3 0 x25_im_a3 4.289339569151169e-10
Cx26_re_a3 x26_re_a3 0 1.0
Gx26_re_a3 0 x26_re_a3 p3 0 0.1414213562373095
Fx26_re_a3 0 x26_re_a3 V3 7.0710678118654755
Rp26_re_re_a3 0 x26_re_a3 5.604106708721165e-10
Gp26_re_im_a3 0 x26_re_a3 x26_im_a3 0 143458007374.04828
Cx26_im_a3 x26_im_a3 0 1.0
Gp26_im_re_a3 0 x26_im_a3 x26_re_a3 0 -143458007374.04828
Rp26_im_im_a3 0 x26_im_a3 5.604106708721165e-10
Cx27_re_a3 x27_re_a3 0 1.0
Gx27_re_a3 0 x27_re_a3 p3 0 0.1414213562373095
Fx27_re_a3 0 x27_re_a3 V3 7.0710678118654755
Rp27_re_re_a3 0 x27_re_a3 4.0415824417463693e-10
Gp27_re_im_a3 0 x27_re_a3 x27_im_a3 0 139191009718.3968
Cx27_im_a3 x27_im_a3 0 1.0
Gp27_im_re_a3 0 x27_im_a3 x27_re_a3 0 -139191009718.3968
Rp27_im_im_a3 0 x27_im_a3 4.0415824417463693e-10
Cx28_re_a3 x28_re_a3 0 1.0
Gx28_re_a3 0 x28_re_a3 p3 0 0.1414213562373095
Fx28_re_a3 0 x28_re_a3 V3 7.0710678118654755
Rp28_re_re_a3 0 x28_re_a3 5.515497777837109e-10
Gp28_re_im_a3 0 x28_re_a3 x28_im_a3 0 135717785993.89098
Cx28_im_a3 x28_im_a3 0 1.0
Gp28_im_re_a3 0 x28_im_a3 x28_re_a3 0 -135717785993.89098
Rp28_im_im_a3 0 x28_im_a3 5.515497777837109e-10
Cx29_re_a3 x29_re_a3 0 1.0
Gx29_re_a3 0 x29_re_a3 p3 0 0.1414213562373095
Fx29_re_a3 0 x29_re_a3 V3 7.0710678118654755
Rp29_re_re_a3 0 x29_re_a3 5.385911467068673e-10
Gp29_re_im_a3 0 x29_re_a3 x29_im_a3 0 130198859531.93167
Cx29_im_a3 x29_im_a3 0 1.0
Gp29_im_re_a3 0 x29_im_a3 x29_re_a3 0 -130198859531.93167
Rp29_im_im_a3 0 x29_im_a3 5.385911467068673e-10
Cx30_re_a3 x30_re_a3 0 1.0
Gx30_re_a3 0 x30_re_a3 p3 0 0.1414213562373095
Fx30_re_a3 0 x30_re_a3 V3 7.0710678118654755
Rp30_re_re_a3 0 x30_re_a3 1.293631499869189e-10
Gp30_re_im_a3 0 x30_re_a3 x30_im_a3 0 125026933526.9245
Cx30_im_a3 x30_im_a3 0 1.0
Gp30_im_re_a3 0 x30_im_a3 x30_re_a3 0 -125026933526.9245
Rp30_im_im_a3 0 x30_im_a3 1.293631499869189e-10
Cx31_re_a3 x31_re_a3 0 1.0
Gx31_re_a3 0 x31_re_a3 p3 0 0.1414213562373095
Fx31_re_a3 0 x31_re_a3 V3 7.0710678118654755
Rp31_re_re_a3 0 x31_re_a3 4.4598309986159816e-10
Gp31_re_im_a3 0 x31_re_a3 x31_im_a3 0 125249512856.41823
Cx31_im_a3 x31_im_a3 0 1.0
Gp31_im_re_a3 0 x31_im_a3 x31_re_a3 0 -125249512856.41823
Rp31_im_im_a3 0 x31_im_a3 4.4598309986159816e-10
Cx32_re_a3 x32_re_a3 0 1.0
Gx32_re_a3 0 x32_re_a3 p3 0 0.1414213562373095
Fx32_re_a3 0 x32_re_a3 V3 7.0710678118654755
Rp32_re_re_a3 0 x32_re_a3 6.806449337893251e-10
Gp32_re_im_a3 0 x32_re_a3 x32_im_a3 0 114377525421.56393
Cx32_im_a3 x32_im_a3 0 1.0
Gp32_im_re_a3 0 x32_im_a3 x32_re_a3 0 -114377525421.56393
Rp32_im_im_a3 0 x32_im_a3 6.806449337893251e-10
Cx33_re_a3 x33_re_a3 0 1.0
Gx33_re_a3 0 x33_re_a3 p3 0 0.1414213562373095
Fx33_re_a3 0 x33_re_a3 V3 7.0710678118654755
Rp33_re_re_a3 0 x33_re_a3 6.827975557481133e-10
Gp33_re_im_a3 0 x33_re_a3 x33_im_a3 0 109880322668.63147
Cx33_im_a3 x33_im_a3 0 1.0
Gp33_im_re_a3 0 x33_im_a3 x33_re_a3 0 -109880322668.63147
Rp33_im_im_a3 0 x33_im_a3 6.827975557481133e-10
Cx34_re_a3 x34_re_a3 0 1.0
Gx34_re_a3 0 x34_re_a3 p3 0 0.1414213562373095
Fx34_re_a3 0 x34_re_a3 V3 7.0710678118654755
Rp34_re_re_a3 0 x34_re_a3 6.414613283370872e-10
Gp34_re_im_a3 0 x34_re_a3 x34_im_a3 0 100363561795.05267
Cx34_im_a3 x34_im_a3 0 1.0
Gp34_im_re_a3 0 x34_im_a3 x34_re_a3 0 -100363561795.05267
Rp34_im_im_a3 0 x34_im_a3 6.414613283370872e-10
Cx35_re_a3 x35_re_a3 0 1.0
Gx35_re_a3 0 x35_re_a3 p3 0 0.1414213562373095
Fx35_re_a3 0 x35_re_a3 V3 7.0710678118654755
Rp35_re_re_a3 0 x35_re_a3 5.255745869778509e-10
Gp35_re_im_a3 0 x35_re_a3 x35_im_a3 0 95922025504.53201
Cx35_im_a3 x35_im_a3 0 1.0
Gp35_im_re_a3 0 x35_im_a3 x35_re_a3 0 -95922025504.53201
Rp35_im_im_a3 0 x35_im_a3 5.255745869778509e-10
Cx36_re_a3 x36_re_a3 0 1.0
Gx36_re_a3 0 x36_re_a3 p3 0 0.1414213562373095
Fx36_re_a3 0 x36_re_a3 V3 7.0710678118654755
Rp36_re_re_a3 0 x36_re_a3 4.701845418472811e-10
Gp36_re_im_a3 0 x36_re_a3 x36_im_a3 0 91827204426.0559
Cx36_im_a3 x36_im_a3 0 1.0
Gp36_im_re_a3 0 x36_im_a3 x36_re_a3 0 -91827204426.0559
Rp36_im_im_a3 0 x36_im_a3 4.701845418472811e-10
Cx37_re_a3 x37_re_a3 0 1.0
Gx37_re_a3 0 x37_re_a3 p3 0 0.1414213562373095
Fx37_re_a3 0 x37_re_a3 V3 7.0710678118654755
Rp37_re_re_a3 0 x37_re_a3 5.1986573840207194e-11
Gp37_re_im_a3 0 x37_re_a3 x37_im_a3 0 72397845044.52003
Cx37_im_a3 x37_im_a3 0 1.0
Gp37_im_re_a3 0 x37_im_a3 x37_re_a3 0 -72397845044.52003
Rp37_im_im_a3 0 x37_im_a3 5.1986573840207194e-11
Cx38_re_a3 x38_re_a3 0 1.0
Gx38_re_a3 0 x38_re_a3 p3 0 0.1414213562373095
Fx38_re_a3 0 x38_re_a3 V3 7.0710678118654755
Rp38_re_re_a3 0 x38_re_a3 6.266691087283841e-10
Gp38_re_im_a3 0 x38_re_a3 x38_im_a3 0 87242951630.81523
Cx38_im_a3 x38_im_a3 0 1.0
Gp38_im_re_a3 0 x38_im_a3 x38_re_a3 0 -87242951630.81523
Rp38_im_im_a3 0 x38_im_a3 6.266691087283841e-10
Cx39_re_a3 x39_re_a3 0 1.0
Gx39_re_a3 0 x39_re_a3 p3 0 0.1414213562373095
Fx39_re_a3 0 x39_re_a3 V3 7.0710678118654755
Rp39_re_re_a3 0 x39_re_a3 5.234864343640884e-10
Gp39_re_im_a3 0 x39_re_a3 x39_im_a3 0 82858757195.85092
Cx39_im_a3 x39_im_a3 0 1.0
Gp39_im_re_a3 0 x39_im_a3 x39_re_a3 0 -82858757195.85092
Rp39_im_im_a3 0 x39_im_a3 5.234864343640884e-10
Cx40_re_a3 x40_re_a3 0 1.0
Gx40_re_a3 0 x40_re_a3 p3 0 0.1414213562373095
Fx40_re_a3 0 x40_re_a3 V3 7.0710678118654755
Rp40_re_re_a3 0 x40_re_a3 5.871156006436874e-10
Gp40_re_im_a3 0 x40_re_a3 x40_im_a3 0 78507674910.57098
Cx40_im_a3 x40_im_a3 0 1.0
Gp40_im_re_a3 0 x40_im_a3 x40_re_a3 0 -78507674910.57098
Rp40_im_im_a3 0 x40_im_a3 5.871156006436874e-10
Cx41_re_a3 x41_re_a3 0 1.0
Gx41_re_a3 0 x41_re_a3 p3 0 0.1414213562373095
Fx41_re_a3 0 x41_re_a3 V3 7.0710678118654755
Rp41_re_re_a3 0 x41_re_a3 7.362920812502898e-10
Gp41_re_im_a3 0 x41_re_a3 x41_im_a3 0 53898762948.71844
Cx41_im_a3 x41_im_a3 0 1.0
Gp41_im_re_a3 0 x41_im_a3 x41_re_a3 0 -53898762948.71844
Rp41_im_im_a3 0 x41_im_a3 7.362920812502898e-10
Cx42_re_a3 x42_re_a3 0 1.0
Gx42_re_a3 0 x42_re_a3 p3 0 0.1414213562373095
Fx42_re_a3 0 x42_re_a3 V3 7.0710678118654755
Rp42_re_re_a3 0 x42_re_a3 6.83072510187094e-10
Gp42_re_im_a3 0 x42_re_a3 x42_im_a3 0 49596203552.090675
Cx42_im_a3 x42_im_a3 0 1.0
Gp42_im_re_a3 0 x42_im_a3 x42_re_a3 0 -49596203552.090675
Rp42_im_im_a3 0 x42_im_a3 6.83072510187094e-10
Cx43_re_a3 x43_re_a3 0 1.0
Gx43_re_a3 0 x43_re_a3 p3 0 0.1414213562373095
Fx43_re_a3 0 x43_re_a3 V3 7.0710678118654755
Rp43_re_re_a3 0 x43_re_a3 7.886851854703573e-10
Gp43_re_im_a3 0 x43_re_a3 x43_im_a3 0 33914448806.74464
Cx43_im_a3 x43_im_a3 0 1.0
Gp43_im_re_a3 0 x43_im_a3 x43_re_a3 0 -33914448806.74464
Rp43_im_im_a3 0 x43_im_a3 7.886851854703573e-10
Cx44_re_a3 x44_re_a3 0 1.0
Gx44_re_a3 0 x44_re_a3 p3 0 0.1414213562373095
Fx44_re_a3 0 x44_re_a3 V3 7.0710678118654755
Rp44_re_re_a3 0 x44_re_a3 6.90773635036418e-10
Gp44_re_im_a3 0 x44_re_a3 x44_im_a3 0 28461055845.680824
Cx44_im_a3 x44_im_a3 0 1.0
Gp44_im_re_a3 0 x44_im_a3 x44_re_a3 0 -28461055845.680824
Rp44_im_im_a3 0 x44_im_a3 6.90773635036418e-10
Cx45_re_a3 x45_re_a3 0 1.0
Gx45_re_a3 0 x45_re_a3 p3 0 0.1414213562373095
Fx45_re_a3 0 x45_re_a3 V3 7.0710678118654755
Rp45_re_re_a3 0 x45_re_a3 6.80191910067349e-10
Gp45_re_im_a3 0 x45_re_a3 x45_im_a3 0 24097859368.009228
Cx45_im_a3 x45_im_a3 0 1.0
Gp45_im_re_a3 0 x45_im_a3 x45_re_a3 0 -24097859368.009228
Rp45_im_im_a3 0 x45_im_a3 6.80191910067349e-10
Cx46_re_a3 x46_re_a3 0 1.0
Gx46_re_a3 0 x46_re_a3 p3 0 0.1414213562373095
Fx46_re_a3 0 x46_re_a3 V3 7.0710678118654755
Rp46_re_re_a3 0 x46_re_a3 3.3632515940909853e-10
Gp46_re_im_a3 0 x46_re_a3 x46_im_a3 0 17535003925.97815
Cx46_im_a3 x46_im_a3 0 1.0
Gp46_im_re_a3 0 x46_im_a3 x46_re_a3 0 -17535003925.97815
Rp46_im_im_a3 0 x46_im_a3 3.3632515940909853e-10
Cx47_re_a3 x47_re_a3 0 1.0
Gx47_re_a3 0 x47_re_a3 p3 0 0.1414213562373095
Fx47_re_a3 0 x47_re_a3 V3 7.0710678118654755
Rp47_re_re_a3 0 x47_re_a3 9.629414892146456e-10
Gp47_re_im_a3 0 x47_re_a3 x47_im_a3 0 11715090574.045237
Cx47_im_a3 x47_im_a3 0 1.0
Gp47_im_re_a3 0 x47_im_a3 x47_re_a3 0 -11715090574.045237
Rp47_im_im_a3 0 x47_im_a3 9.629414892146456e-10
Cx48_re_a3 x48_re_a3 0 1.0
Gx48_re_a3 0 x48_re_a3 p3 0 0.1414213562373095
Fx48_re_a3 0 x48_re_a3 V3 7.0710678118654755
Rp48_re_re_a3 0 x48_re_a3 8.037389283921146e-10
Gp48_re_im_a3 0 x48_re_a3 x48_im_a3 0 8411555387.1175995
Cx48_im_a3 x48_im_a3 0 1.0
Gp48_im_re_a3 0 x48_im_a3 x48_re_a3 0 -8411555387.1175995
Rp48_im_im_a3 0 x48_im_a3 8.037389283921146e-10
Cx49_re_a3 x49_re_a3 0 1.0
Gx49_re_a3 0 x49_re_a3 p3 0 0.1414213562373095
Fx49_re_a3 0 x49_re_a3 V3 7.0710678118654755
Rp49_re_re_a3 0 x49_re_a3 2.3953032926638584e-09
Gp49_re_im_a3 0 x49_re_a3 x49_im_a3 0 7281971191.968741
Cx49_im_a3 x49_im_a3 0 1.0
Gp49_im_re_a3 0 x49_im_a3 x49_re_a3 0 -7281971191.968741
Rp49_im_im_a3 0 x49_im_a3 2.3953032926638584e-09
Cx50_re_a3 x50_re_a3 0 1.0
Gx50_re_a3 0 x50_re_a3 p3 0 0.1414213562373095
Fx50_re_a3 0 x50_re_a3 V3 7.0710678118654755
Rp50_re_re_a3 0 x50_re_a3 9.291538099627055e-09
Gp50_re_im_a3 0 x50_re_a3 x50_im_a3 0 5485192888.061847
Cx50_im_a3 x50_im_a3 0 1.0
Gp50_im_re_a3 0 x50_im_a3 x50_re_a3 0 -5485192888.061847
Rp50_im_im_a3 0 x50_im_a3 9.291538099627055e-09
Cx51_re_a3 x51_re_a3 0 1.0
Gx51_re_a3 0 x51_re_a3 p3 0 0.1414213562373095
Fx51_re_a3 0 x51_re_a3 V3 7.0710678118654755
Rp51_re_re_a3 0 x51_re_a3 1.1361341983747998e-08
Gp51_re_im_a3 0 x51_re_a3 x51_im_a3 0 4208225203.7586317
Cx51_im_a3 x51_im_a3 0 1.0
Gp51_im_re_a3 0 x51_im_a3 x51_re_a3 0 -4208225203.7586317
Rp51_im_im_a3 0 x51_im_a3 1.1361341983747998e-08
Cx52_re_a3 x52_re_a3 0 1.0
Gx52_re_a3 0 x52_re_a3 p3 0 0.1414213562373095
Fx52_re_a3 0 x52_re_a3 V3 7.0710678118654755
Rp52_re_re_a3 0 x52_re_a3 6.593416593325721e-09
Gp52_re_im_a3 0 x52_re_a3 x52_im_a3 0 3907713961.770896
Cx52_im_a3 x52_im_a3 0 1.0
Gp52_im_re_a3 0 x52_im_a3 x52_re_a3 0 -3907713961.770896
Rp52_im_im_a3 0 x52_im_a3 6.593416593325721e-09
Cx53_re_a3 x53_re_a3 0 1.0
Gx53_re_a3 0 x53_re_a3 p3 0 0.1414213562373095
Fx53_re_a3 0 x53_re_a3 V3 7.0710678118654755
Rp53_re_re_a3 0 x53_re_a3 4.598865760619702e-09
Gp53_re_im_a3 0 x53_re_a3 x53_im_a3 0 3138989640.311349
Cx53_im_a3 x53_im_a3 0 1.0
Gp53_im_re_a3 0 x53_im_a3 x53_re_a3 0 -3138989640.311349
Rp53_im_im_a3 0 x53_im_a3 4.598865760619702e-09
Cx54_re_a3 x54_re_a3 0 1.0
Gx54_re_a3 0 x54_re_a3 p3 0 0.1414213562373095
Fx54_re_a3 0 x54_re_a3 V3 7.0710678118654755
Rp54_re_re_a3 0 x54_re_a3 5.013329113974378e-09
Gp54_re_im_a3 0 x54_re_a3 x54_im_a3 0 2763239017.283009
Cx54_im_a3 x54_im_a3 0 1.0
Gp54_im_re_a3 0 x54_im_a3 x54_re_a3 0 -2763239017.283009
Rp54_im_im_a3 0 x54_im_a3 5.013329113974378e-09
Cx55_re_a3 x55_re_a3 0 1.0
Gx55_re_a3 0 x55_re_a3 p3 0 0.1414213562373095
Fx55_re_a3 0 x55_re_a3 V3 7.0710678118654755
Rp55_re_re_a3 0 x55_re_a3 5.489391819401233e-09
Gp55_re_im_a3 0 x55_re_a3 x55_im_a3 0 2337692824.826442
Cx55_im_a3 x55_im_a3 0 1.0
Gp55_im_re_a3 0 x55_im_a3 x55_re_a3 0 -2337692824.826442
Rp55_im_im_a3 0 x55_im_a3 5.489391819401233e-09
Cx56_re_a3 x56_re_a3 0 1.0
Gx56_re_a3 0 x56_re_a3 p3 0 0.1414213562373095
Fx56_re_a3 0 x56_re_a3 V3 7.0710678118654755
Rp56_re_re_a3 0 x56_re_a3 5.715836849677958e-09
Gp56_re_im_a3 0 x56_re_a3 x56_im_a3 0 1907462400.4905782
Cx56_im_a3 x56_im_a3 0 1.0
Gp56_im_re_a3 0 x56_im_a3 x56_re_a3 0 -1907462400.4905782
Rp56_im_im_a3 0 x56_im_a3 5.715836849677958e-09
Cx57_re_a3 x57_re_a3 0 1.0
Gx57_re_a3 0 x57_re_a3 p3 0 0.1414213562373095
Fx57_re_a3 0 x57_re_a3 V3 7.0710678118654755
Rp57_re_re_a3 0 x57_re_a3 5.740354751724126e-09
Gp57_re_im_a3 0 x57_re_a3 x57_im_a3 0 1043629713.8561413
Cx57_im_a3 x57_im_a3 0 1.0
Gp57_im_re_a3 0 x57_im_a3 x57_re_a3 0 -1043629713.8561413
Rp57_im_im_a3 0 x57_im_a3 5.740354751724126e-09
Cx58_re_a3 x58_re_a3 0 1.0
Gx58_re_a3 0 x58_re_a3 p3 0 0.1414213562373095
Fx58_re_a3 0 x58_re_a3 V3 7.0710678118654755
Rp58_re_re_a3 0 x58_re_a3 5.783268392817006e-09
Gp58_re_im_a3 0 x58_re_a3 x58_im_a3 0 1474144465.2759433
Cx58_im_a3 x58_im_a3 0 1.0
Gp58_im_re_a3 0 x58_im_a3 x58_re_a3 0 -1474144465.2759433
Rp58_im_im_a3 0 x58_im_a3 5.783268392817006e-09
Cx59_re_a3 x59_re_a3 0 1.0
Gx59_re_a3 0 x59_re_a3 p3 0 0.1414213562373095
Fx59_re_a3 0 x59_re_a3 V3 7.0710678118654755
Rp59_re_re_a3 0 x59_re_a3 5.734252219761168e-09
Gp59_re_im_a3 0 x59_re_a3 x59_im_a3 0 201137530.81086907
Cx59_im_a3 x59_im_a3 0 1.0
Gp59_im_re_a3 0 x59_im_a3 x59_re_a3 0 -201137530.81086907
Rp59_im_im_a3 0 x59_im_a3 5.734252219761168e-09
Cx60_re_a3 x60_re_a3 0 1.0
Gx60_re_a3 0 x60_re_a3 p3 0 0.1414213562373095
Fx60_re_a3 0 x60_re_a3 V3 7.0710678118654755
Rp60_re_re_a3 0 x60_re_a3 5.652786094011291e-09
Gp60_re_im_a3 0 x60_re_a3 x60_im_a3 0 618651646.662869
Cx60_im_a3 x60_im_a3 0 1.0
Gp60_im_re_a3 0 x60_im_a3 x60_re_a3 0 -618651646.662869
Rp60_im_im_a3 0 x60_im_a3 5.652786094011291e-09
*
* Port network for port 4
V4 p4 s4 0
R4 s4 0 50.0
Gd4_1 0 s4 p1 0 1.2376811455709222e-06
Fd4_1 0 s4 V1 6.188405727854612e-05
Gr1_re_4_1 0 s4 x1_re_a1 0 -8825339626.1789
Gr1_im_4_1 0 s4 x1_im_a1 0 13789219913.652271
Gr2_re_4_1 0 s4 x2_re_a1 0 -1695664102268912.0
Gr2_im_4_1 0 s4 x2_im_a1 0 1484659572002630.0
Gr3_re_4_1 0 s4 x3_re_a1 0 2.1870906824193624e+16
Gr3_im_4_1 0 s4 x3_im_a1 0 1.5761427106408028e+16
Gr4_re_4_1 0 s4 x4_re_a1 0 -3.4096826136756372e+16
Gr4_im_4_1 0 s4 x4_im_a1 0 -6.871944697105514e+16
Gr5_re_4_1 0 s4 x5_re_a1 0 -3.3876837316646285e+17
Gr5_im_4_1 0 s4 x5_im_a1 0 7.481991326713458e+16
Gr6_re_4_1 0 s4 x6_re_a1 0 -4.354450921617694e+16
Gr6_im_4_1 0 s4 x6_im_a1 0 -3.465073118418927e+17
Gr7_re_4_1 0 s4 x7_re_a1 0 -2.845237620983165e+17
Gr7_im_4_1 0 s4 x7_im_a1 0 8.855442766319269e+17
Gr8_re_4_1 0 s4 x8_re_a1 0 -7.303948246151302e+17
Gr8_im_4_1 0 s4 x8_im_a1 0 7.326173183820116e+17
Gr9_re_4_1 0 s4 x9_re_a1 0 2.0335716694622118e+18
Gr9_im_4_1 0 s4 x9_im_a1 0 3.731236308163898e+16
Gr10_re_4_1 0 s4 x10_re_a1 0 2.5017471949062746e+19
Gr10_im_4_1 0 s4 x10_im_a1 0 7.24641684538106e+18
Gr11_re_4_1 0 s4 x11_re_a1 0 7.309924810337089e+18
Gr11_im_4_1 0 s4 x11_im_a1 0 -1.7364677025426213e+19
Gr12_re_4_1 0 s4 x12_re_a1 0 -7.554749770840146e+19
Gr12_im_4_1 0 s4 x12_im_a1 0 -1.93960731486318e+17
Gr13_re_4_1 0 s4 x13_re_a1 0 1.9429244990312456e+19
Gr13_im_4_1 0 s4 x13_im_a1 0 1.4267227720328616e+19
Gr14_re_4_1 0 s4 x14_re_a1 0 1.1417450313426137e+19
Gr14_im_4_1 0 s4 x14_im_a1 0 -1.9383080772875983e+18
Gr15_re_4_1 0 s4 x15_re_a1 0 1.5416360312160662e+19
Gr15_im_4_1 0 s4 x15_im_a1 0 8.826948145914596e+18
Gr16_re_4_1 0 s4 x16_re_a1 0 4.324389828529366e+19
Gr16_im_4_1 0 s4 x16_im_a1 0 2.0982839575396303e+19
Gr17_re_4_1 0 s4 x17_re_a1 0 -1.7059611155648412e+19
Gr17_im_4_1 0 s4 x17_im_a1 0 -3.2107152675821867e+19
Gr18_re_4_1 0 s4 x18_re_a1 0 1.0390469493614438e+19
Gr18_im_4_1 0 s4 x18_im_a1 0 -9.9693214686581e+17
Gr19_re_4_1 0 s4 x19_re_a1 0 -4.81814816084677e+19
Gr19_im_4_1 0 s4 x19_im_a1 0 -2.6577179299244597e+19
Gr20_re_4_1 0 s4 x20_re_a1 0 8.872169352040454e+17
Gr20_im_4_1 0 s4 x20_im_a1 0 3.271512536789709e+16
Gr21_re_4_1 0 s4 x21_re_a1 0 -4.403194558586395e+19
Gr21_im_4_1 0 s4 x21_im_a1 0 6.534060765230149e+18
Gr22_re_4_1 0 s4 x22_re_a1 0 1.3974968728037097e+19
Gr22_im_4_1 0 s4 x22_im_a1 0 9.041666744954574e+18
Gr23_re_4_1 0 s4 x23_re_a1 0 -1.6286014550593034e+19
Gr23_im_4_1 0 s4 x23_im_a1 0 1.6751219012631063e+19
Gr24_re_4_1 0 s4 x24_re_a1 0 2.9977056158431613e+19
Gr24_im_4_1 0 s4 x24_im_a1 0 1.09736638152063e+18
Gr25_re_4_1 0 s4 x25_re_a1 0 1.2606491372854318e+18
Gr25_im_4_1 0 s4 x25_im_a1 0 1.083616728726569e+19
Gr26_re_4_1 0 s4 x26_re_a1 0 4.721342201779181e+19
Gr26_im_4_1 0 s4 x26_im_a1 0 1.7258717117460206e+19
Gr27_re_4_1 0 s4 x27_re_a1 0 3.5952852145423027e+18
Gr27_im_4_1 0 s4 x27_im_a1 0 2.140122091763491e+18
Gr28_re_4_1 0 s4 x28_re_a1 0 7.739413444454031e+18
Gr28_im_4_1 0 s4 x28_im_a1 0 -1.0759751758309538e+19
Gr29_re_4_1 0 s4 x29_re_a1 0 2.3692124944532337e+19
Gr29_im_4_1 0 s4 x29_im_a1 0 1.8454512279943967e+19
Gr30_re_4_1 0 s4 x30_re_a1 0 9.879083233231897e+18
Gr30_im_4_1 0 s4 x30_im_a1 0 -5.4286663322061e+19
Gr31_re_4_1 0 s4 x31_re_a1 0 -2.4192040291365175e+19
Gr31_im_4_1 0 s4 x31_im_a1 0 -7.581267939494906e+18
Gr32_re_4_1 0 s4 x32_re_a1 0 -1.0282912902875677e+19
Gr32_im_4_1 0 s4 x32_im_a1 0 6.108719531557147e+18
Gr33_re_4_1 0 s4 x33_re_a1 0 -1.9003135257468772e+19
Gr33_im_4_1 0 s4 x33_im_a1 0 -1.411197353097162e+19
Gr34_re_4_1 0 s4 x34_re_a1 0 -2.9120247733501526e+19
Gr34_im_4_1 0 s4 x34_im_a1 0 -7.385277413009306e+18
Gr35_re_4_1 0 s4 x35_re_a1 0 -1.2202924805508184e+19
Gr35_im_4_1 0 s4 x35_im_a1 0 -1.4743944804200153e+19
Gr36_re_4_1 0 s4 x36_re_a1 0 -4.356244077223395e+17
Gr36_im_4_1 0 s4 x36_im_a1 0 6.232141202282928e+18
Gr37_re_4_1 0 s4 x37_re_a1 0 6.987799586801559e+19
Gr37_im_4_1 0 s4 x37_im_a1 0 5.58952044384132e+19
Gr38_re_4_1 0 s4 x38_re_a1 0 -2.4048714274771415e+19
Gr38_im_4_1 0 s4 x38_im_a1 0 -1.2768875037343265e+19
Gr39_re_4_1 0 s4 x39_re_a1 0 -3.88925834052806e+18
Gr39_im_4_1 0 s4 x39_im_a1 0 -1.2596746993679649e+19
Gr40_re_4_1 0 s4 x40_re_a1 0 -3.216599499007155e+18
Gr40_im_4_1 0 s4 x40_im_a1 0 2.4359255547966206e+19
Gr41_re_4_1 0 s4 x41_re_a1 0 1.0564107671801917e+19
Gr41_im_4_1 0 s4 x41_im_a1 0 -1.6774909433731195e+19
Gr42_re_4_1 0 s4 x42_re_a1 0 -6.962067915729849e+18
Gr42_im_4_1 0 s4 x42_im_a1 0 7.086211767393246e+18
Gr43_re_4_1 0 s4 x43_re_a1 0 1.9718588294682784e+19
Gr43_im_4_1 0 s4 x43_im_a1 0 1.7053408228268726e+18
Gr44_re_4_1 0 s4 x44_re_a1 0 9.823546398878e+18
Gr44_im_4_1 0 s4 x44_im_a1 0 -1.142620627696045e+19
Gr45_re_4_1 0 s4 x45_re_a1 0 1.9199483303518274e+19
Gr45_im_4_1 0 s4 x45_im_a1 0 -8.673653183310511e+17
Gr46_re_4_1 0 s4 x46_re_a1 0 -1.9752763000085246e+19
Gr46_im_4_1 0 s4 x46_im_a1 0 -1.2888969862568966e+19
Gr47_re_4_1 0 s4 x47_re_a1 0 1.5966044144120164e+19
Gr47_im_4_1 0 s4 x47_im_a1 0 -8.524840048468378e+18
Gr48_re_4_1 0 s4 x48_re_a1 0 9.43580753848014e+18
Gr48_im_4_1 0 s4 x48_im_a1 0 -9.883541483429612e+17
Gr49_re_4_1 0 s4 x49_re_a1 0 5.622021541647688e+18
Gr49_im_4_1 0 s4 x49_im_a1 0 2.183723846387249e+18
Gr50_re_4_1 0 s4 x50_re_a1 0 -2.6798775620486513e+18
Gr50_im_4_1 0 s4 x50_im_a1 0 1.601778787918977e+18
Gr51_re_4_1 0 s4 x51_re_a1 0 -7.957588452499224e+18
Gr51_im_4_1 0 s4 x51_im_a1 0 7.937021356461742e+17
Gr52_re_4_1 0 s4 x52_re_a1 0 -8.88534874734737e+18
Gr52_im_4_1 0 s4 x52_im_a1 0 6.232068586825262e+17
Gr53_re_4_1 0 s4 x53_re_a1 0 -1.0751013207461315e+19
Gr53_im_4_1 0 s4 x53_im_a1 0 3.2206364673905094e+17
Gr54_re_4_1 0 s4 x54_re_a1 0 -1.1472041291850885e+19
Gr54_im_4_1 0 s4 x54_im_a1 0 2.2488640446694006e+17
Gr55_re_4_1 0 s4 x55_re_a1 0 -1.1818896779834493e+19
Gr55_im_4_1 0 s4 x55_im_a1 0 1.3934605278970149e+17
Gr56_re_4_1 0 s4 x56_re_a1 0 -1.1044079426821065e+19
Gr56_im_4_1 0 s4 x56_im_a1 0 7.70518964273609e+16
Gr57_re_4_1 0 s4 x57_re_a1 0 -3.6054813291859405e+18
Gr57_im_4_1 0 s4 x57_im_a1 0 1.326180262061172e+16
Gr58_re_4_1 0 s4 x58_re_a1 0 -8.220084703068087e+18
Gr58_im_4_1 0 s4 x58_im_a1 0 3.624370615653027e+16
Gr59_re_4_1 0 s4 x59_re_a1 0 -1.9185595742025544e+16
Gr59_im_4_1 0 s4 x59_im_a1 0 278284712432143.47
Gr60_re_4_1 0 s4 x60_re_a1 0 -6.076172691797157e+17
Gr60_im_4_1 0 s4 x60_im_a1 0 3065173285735595.0
Gd4_2 0 s4 p2 0 0.00020482020715549917
Fd4_2 0 s4 V2 0.010241010357774959
Gr1_re_4_2 0 s4 x1_re_a2 0 -7323460940.340374
Gr1_im_4_2 0 s4 x1_im_a2 0 13027790902.665964
Gr2_re_4_2 0 s4 x2_re_a2 0 -1488979552223360.2
Gr2_im_4_2 0 s4 x2_im_a2 0 1416431983019238.5
Gr3_re_4_2 0 s4 x3_re_a2 0 2.050204166524271e+16
Gr3_im_4_2 0 s4 x3_im_a2 0 1.3562157431840648e+16
Gr4_re_4_2 0 s4 x4_re_a2 0 -3.3489999842914636e+16
Gr4_im_4_2 0 s4 x4_im_a2 0 -6.1406884259052776e+16
Gr5_re_4_2 0 s4 x5_re_a2 0 -3.083489522281133e+17
Gr5_im_4_2 0 s4 x5_im_a2 0 7.898660281381184e+16
Gr6_re_4_2 0 s4 x6_re_a2 0 -5.0768322762691704e+16
Gr6_im_4_2 0 s4 x6_im_a2 0 -3.1424935789101466e+17
Gr7_re_4_2 0 s4 x7_re_a2 0 -2.3181035676841923e+17
Gr7_im_4_2 0 s4 x7_im_a2 0 8.155237709956992e+17
Gr8_re_4_2 0 s4 x8_re_a2 0 -6.450435543772068e+17
Gr8_im_4_2 0 s4 x8_im_a2 0 6.874856435215926e+17
Gr9_re_4_2 0 s4 x9_re_a2 0 1.853442182755964e+18
Gr9_im_4_2 0 s4 x9_im_a2 0 -1.7072344726188246e+16
Gr10_re_4_2 0 s4 x10_re_a2 0 2.293893490076526e+19
Gr10_im_4_2 0 s4 x10_im_a2 0 6.089004047114037e+18
Gr11_re_4_2 0 s4 x11_re_a2 0 6.329962818963485e+18
Gr11_im_4_2 0 s4 x11_im_a2 0 -1.5956361335318276e+19
Gr12_re_4_2 0 s4 x12_re_a2 0 -6.885838886868459e+19
Gr12_im_4_2 0 s4 x12_im_a2 0 1.0612849652277491e+18
Gr13_re_4_2 0 s4 x13_re_a2 0 1.7855413572308257e+19
Gr13_im_4_2 0 s4 x13_im_a2 0 1.2783044922020024e+19
Gr14_re_4_2 0 s4 x14_re_a2 0 1.0366428603245412e+19
Gr14_im_4_2 0 s4 x14_im_a2 0 -1.3773786346081434e+18
Gr15_re_4_2 0 s4 x15_re_a2 0 1.4312960255277963e+19
Gr15_im_4_2 0 s4 x15_im_a2 0 7.406634318467215e+18
Gr16_re_4_2 0 s4 x16_re_a2 0 3.9666650253098525e+19
Gr16_im_4_2 0 s4 x16_im_a2 0 1.8455697756145787e+19
Gr17_re_4_2 0 s4 x17_re_a2 0 -1.573902596575291e+19
Gr17_im_4_2 0 s4 x17_im_a2 0 -2.9193295445689168e+19
Gr18_re_4_2 0 s4 x18_re_a2 0 9.35530792116426e+18
Gr18_im_4_2 0 s4 x18_im_a2 0 -1.2828480170911322e+18
Gr19_re_4_2 0 s4 x19_re_a2 0 -4.4203921064624824e+19
Gr19_im_4_2 0 s4 x19_im_a2 0 -2.3721792152827826e+19
Gr20_re_4_2 0 s4 x20_re_a2 0 5.655710772262424e+17
Gr20_im_4_2 0 s4 x20_im_a2 0 7.595245411427122e+16
Gr21_re_4_2 0 s4 x21_re_a2 0 -4.002116408485962e+19
Gr21_im_4_2 0 s4 x21_im_a2 0 6.480461795584587e+18
Gr22_re_4_2 0 s4 x22_re_a2 0 1.2564703109302434e+19
Gr22_im_4_2 0 s4 x22_im_a2 0 8.404044932800868e+18
Gr23_re_4_2 0 s4 x23_re_a2 0 -1.4562903661509788e+19
Gr23_im_4_2 0 s4 x23_im_a2 0 1.5556597172068033e+19
Gr24_re_4_2 0 s4 x24_re_a2 0 2.7211705131541045e+19
Gr24_im_4_2 0 s4 x24_im_a2 0 1.1495359159539494e+18
Gr25_re_4_2 0 s4 x25_re_a2 0 1.5156331706886346e+18
Gr25_im_4_2 0 s4 x25_im_a2 0 9.812949614269987e+18
Gr26_re_4_2 0 s4 x26_re_a2 0 4.308814211436417e+19
Gr26_im_4_2 0 s4 x26_im_a2 0 1.5333988386997332e+19
Gr27_re_4_2 0 s4 x27_re_a2 0 3.489905901583273e+18
Gr27_im_4_2 0 s4 x27_im_a2 0 1.7927014337589379e+18
Gr28_re_4_2 0 s4 x28_re_a2 0 7.010732812999099e+18
Gr28_im_4_2 0 s4 x28_im_a2 0 -9.793421411618662e+18
Gr29_re_4_2 0 s4 x29_re_a2 0 2.1808688063385866e+19
Gr29_im_4_2 0 s4 x29_im_a2 0 1.633817369173056e+19
Gr30_re_4_2 0 s4 x30_re_a2 0 8.479649639664856e+18
Gr30_im_4_2 0 s4 x30_im_a2 0 -4.997866946795887e+19
Gr31_re_4_2 0 s4 x31_re_a2 0 -2.1929905429070918e+19
Gr31_im_4_2 0 s4 x31_im_a2 0 -6.678439913495562e+18
Gr32_re_4_2 0 s4 x32_re_a2 0 -9.26197519475918e+18
Gr32_im_4_2 0 s4 x32_im_a2 0 5.146073769488186e+18
Gr33_re_4_2 0 s4 x33_re_a2 0 -1.7512726137245401e+19
Gr33_im_4_2 0 s4 x33_im_a2 0 -1.2490230200279015e+19
Gr34_re_4_2 0 s4 x34_re_a2 0 -2.63989975040512e+19
Gr34_im_4_2 0 s4 x34_im_a2 0 -6.910144742491651e+18
Gr35_re_4_2 0 s4 x35_re_a2 0 -1.1362063971048405e+19
Gr35_im_4_2 0 s4 x35_im_a2 0 -1.3174334880478941e+19
Gr36_re_4_2 0 s4 x36_re_a2 0 -5.502994816170988e+17
Gr36_im_4_2 0 s4 x36_im_a2 0 5.647349943721065e+18
Gr37_re_4_2 0 s4 x37_re_a2 0 6.4281258925826105e+19
Gr37_im_4_2 0 s4 x37_im_a2 0 5.170738970377411e+19
Gr38_re_4_2 0 s4 x38_re_a2 0 -2.1918920254043197e+19
Gr38_im_4_2 0 s4 x38_im_a2 0 -1.1459916805785141e+19
Gr39_re_4_2 0 s4 x39_re_a2 0 -3.877518311708575e+18
Gr39_im_4_2 0 s4 x39_im_a2 0 -1.121369090532737e+19
Gr40_re_4_2 0 s4 x40_re_a2 0 -2.813646848691958e+18
Gr40_im_4_2 0 s4 x40_im_a2 0 2.2141630163507466e+19
Gr41_re_4_2 0 s4 x41_re_a2 0 1.0055482794460594e+19
Gr41_im_4_2 0 s4 x41_im_a2 0 -1.4728474145952244e+19
Gr42_re_4_2 0 s4 x42_re_a2 0 -6.530483458822867e+18
Gr42_im_4_2 0 s4 x42_im_a2 0 5.79906012283896e+18
Gr43_re_4_2 0 s4 x43_re_a2 0 1.7935676172749666e+19
Gr43_im_4_2 0 s4 x43_im_a2 0 1.1666126664295816e+18
Gr44_re_4_2 0 s4 x44_re_a2 0 8.949753887813755e+18
Gr44_im_4_2 0 s4 x44_im_a2 0 -1.039118155798409e+19
Gr45_re_4_2 0 s4 x45_re_a2 0 1.7331626579324465e+19
Gr45_im_4_2 0 s4 x45_im_a2 0 -1.2920618819697336e+18
Gr46_re_4_2 0 s4 x46_re_a2 0 -1.7961764595156066e+19
Gr46_im_4_2 0 s4 x46_im_a2 0 -1.1913352635413185e+19
Gr47_re_4_2 0 s4 x47_re_a2 0 1.439328766609115e+19
Gr47_im_4_2 0 s4 x47_im_a2 0 -7.990148885166574e+18
Gr48_re_4_2 0 s4 x48_re_a2 0 8.443534327871932e+18
Gr48_im_4_2 0 s4 x48_im_a2 0 -1.165347478158219e+18
Gr49_re_4_2 0 s4 x49_re_a2 0 5.024017185543776e+18
Gr49_im_4_2 0 s4 x49_im_a2 0 1.7851932897467546e+18
Gr50_re_4_2 0 s4 x50_re_a2 0 -2.4716388528223693e+18
Gr50_im_4_2 0 s4 x50_im_a2 0 1.3615679711332854e+18
Gr51_re_4_2 0 s4 x51_re_a2 0 -7.243906908340592e+18
Gr51_im_4_2 0 s4 x51_im_a2 0 6.77635738229507e+17
Gr52_re_4_2 0 s4 x52_re_a2 0 -8.086661974793506e+18
Gr52_im_4_2 0 s4 x52_im_a2 0 5.3130384242918394e+17
Gr53_re_4_2 0 s4 x53_re_a2 0 -9.776217292460198e+18
Gr53_im_4_2 0 s4 x53_im_a2 0 2.743209003719758e+17
Gr54_re_4_2 0 s4 x54_re_a2 0 -1.0425880614467176e+19
Gr54_im_4_2 0 s4 x54_im_a2 0 1.917912353858629e+17
Gr55_re_4_2 0 s4 x55_re_a2 0 -1.0735994737673654e+19
Gr55_im_4_2 0 s4 x55_im_a2 0 1.1897903969484256e+17
Gr56_re_4_2 0 s4 x56_re_a2 0 -1.00289670072257e+19
Gr56_im_4_2 0 s4 x56_im_a2 0 6.5835295157933864e+16
Gr57_re_4_2 0 s4 x57_re_a2 0 -3.2730228626097183e+18
Gr57_im_4_2 0 s4 x57_im_a2 0 1.133786343038695e+16
Gr58_re_4_2 0 s4 x58_re_a2 0 -7.463058371709615e+18
Gr58_im_4_2 0 s4 x58_im_a2 0 3.0981399431493616e+16
Gr59_re_4_2 0 s4 x59_re_a2 0 -1.7414473807181508e+16
Gr59_im_4_2 0 s4 x59_im_a2 0 238034918079067.22
Gr60_re_4_2 0 s4 x60_re_a2 0 -5.5155306803445485e+17
Gr60_im_4_2 0 s4 x60_im_a2 0 2620692093086835.5
Gd4_3 0 s4 p3 0 1.9991811693356707e-06
Fd4_3 0 s4 V3 9.995905846678355e-05
Gr1_re_4_3 0 s4 x1_re_a3 0 -7300385071.655788
Gr1_im_4_3 0 s4 x1_im_a3 0 8107345292.521746
Gr2_re_4_3 0 s4 x2_re_a3 0 -1226981977974230.0
Gr2_im_4_3 0 s4 x2_im_a3 0 848038941749477.9
Gr3_re_4_3 0 s4 x3_re_a3 0 1.3210547261824498e+16
Gr3_im_4_3 0 s4 x3_im_a3 0 1.196433810569839e+16
Gr4_re_4_3 0 s4 x4_re_a3 0 -1.7484804991978826e+16
Gr4_im_4_3 0 s4 x4_im_a3 0 -4.7560523029305e+16
Gr5_re_4_3 0 s4 x5_re_a3 0 -2.2310118374375517e+17
Gr5_im_4_3 0 s4 x5_im_a3 0 2.6173610365967604e+16
Gr6_re_4_3 0 s4 x6_re_a3 0 -5883968685818266.0
Gr6_im_4_3 0 s4 x6_im_a3 0 -2.3014584309454294e+17
Gr7_re_4_3 0 s4 x7_re_a3 0 -2.4266027235255552e+17
Gr7_im_4_3 0 s4 x7_im_a3 0 5.624395146583828e+17
Gr8_re_4_3 0 s4 x8_re_a3 0 -5.200962596674769e+17
Gr8_im_4_3 0 s4 x8_im_a3 0 4.3796571901306746e+17
Gr9_re_4_3 0 s4 x9_re_a3 0 1.327650562010568e+18
Gr9_im_4_3 0 s4 x9_im_a3 0 1.3075057325878341e+17
Gr10_re_4_3 0 s4 x10_re_a3 0 1.6011645897294258e+19
Gr10_im_4_3 0 s4 x10_im_a3 0 5.8073490084434e+18
Gr11_re_4_3 0 s4 x11_re_a3 0 5.462356592143628e+18
Gr11_im_4_3 0 s4 x11_im_a3 0 -1.1033504154692588e+19
Gr12_re_4_3 0 s4 x12_re_a3 0 -4.914588539216205e+19
Gr12_im_4_3 0 s4 x12_im_a3 0 -2.763990079611838e+18
Gr13_re_4_3 0 s4 x13_re_a3 0 1.2300002629733345e+19
Gr13_im_4_3 0 s4 x13_im_a3 0 9.73925954027516e+18
Gr14_re_4_3 0 s4 x14_re_a3 0 7.398571354452321e+18
Gr14_im_4_3 0 s4 x14_im_a3 0 -2.0657303093494623e+18
Gr15_re_4_3 0 s4 x15_re_a3 0 9.542395638541115e+18
Gr15_im_4_3 0 s4 x15_im_a3 0 7.111350889513614e+18
Gr16_re_4_3 0 s4 x16_re_a3 0 2.755802338955178e+19
Gr16_im_4_3 0 s4 x16_im_a3 0 1.5064140048356995e+19
Gr17_re_4_3 0 s4 x17_re_a3 0 -1.0626242022783527e+19
Gr17_im_4_3 0 s4 x17_im_a3 0 -2.0972423019223015e+19
Gr18_re_4_3 0 s4 x18_re_a3 0 7.031012451848944e+18
Gr18_im_4_3 0 s4 x18_im_a3 0 1.323156553159314e+17
Gr19_re_4_3 0 s4 x19_re_a3 0 -3.062969469625758e+19
Gr19_im_4_3 0 s4 x19_im_a3 0 -1.8341084915008887e+19
Gr20_re_4_3 0 s4 x20_re_a3 0 1.0821177458680434e+18
Gr20_im_4_3 0 s4 x20_im_a3 0 -1.1506156202097331e+17
Gr21_re_4_3 0 s4 x21_re_a3 0 -2.8813361747933405e+19
Gr21_im_4_3 0 s4 x21_im_a3 0 3.101140036415342e+18
Gr22_re_4_3 0 s4 x22_re_a3 0 9.377939793676095e+18
Gr22_im_4_3 0 s4 x22_im_a3 0 5.486026661284503e+18
Gr23_re_4_3 0 s4 x23_re_a3 0 -1.118809950889654e+19
Gr23_im_4_3 0 s4 x23_im_a3 0 1.0254859033869101e+19
Gr24_re_4_3 0 s4 x24_re_a3 0 1.9608939814796984e+19
Gr24_im_4_3 0 s4 x24_im_a3 0 3.92690120953171e+17
Gr25_re_4_3 0 s4 x25_re_a3 0 3.48267327950118e+16
Gr25_im_4_3 0 s4 x25_im_a3 0 7.19782421670195e+18
Gr26_re_4_3 0 s4 x26_re_a3 0 3.0468150377479266e+19
Gr26_im_4_3 0 s4 x26_im_a3 0 1.20468744983706e+19
Gr27_re_4_3 0 s4 x27_re_a3 0 1.8888353444359265e+18
Gr27_im_4_3 0 s4 x27_im_a3 0 1.7512320734483804e+18
Gr28_re_4_3 0 s4 x28_re_a3 0 5.103467057012569e+18
Gr28_im_4_3 0 s4 x28_im_a3 0 -6.991376521420038e+18
Gr29_re_4_3 0 s4 x29_re_a3 0 1.4915388191821703e+19
Gr29_im_4_3 0 s4 x29_im_a3 0 1.3011084919173102e+19
Gr30_re_4_3 0 s4 x30_re_a3 0 7.600639631770248e+18
Gr30_im_4_3 0 s4 x30_im_a3 0 -3.41014749364527e+19
Gr31_re_4_3 0 s4 x31_re_a3 0 -1.5929418166838864e+19
Gr31_im_4_3 0 s4 x31_im_a3 0 -5.39942105540717e+18
Gr32_re_4_3 0 s4 x32_re_a3 0 -6.848093767906125e+18
Gr32_im_4_3 0 s4 x32_im_a3 0 4.867050807247903e+18
Gr33_re_4_3 0 s4 x33_re_a3 0 -1.191087071511275e+19
Gr33_im_4_3 0 s4 x33_im_a3 0 -9.957340329099321e+18
Gr34_re_4_3 0 s4 x34_re_a3 0 -1.9126527828327666e+19
Gr34_im_4_3 0 s4 x34_im_a3 0 -4.3893029294343014e+18
Gr35_re_4_3 0 s4 x35_re_a3 0 -7.39521795862519e+18
Gr35_im_4_3 0 s4 x35_im_a3 0 -1.0132688791792916e+19
Gr36_re_4_3 0 s4 x36_re_a3 0 4.99934623373843e+16
Gr36_im_4_3 0 s4 x36_im_a3 0 4.0896301423856507e+18
Gr37_re_4_3 0 s4 x37_re_a3 0 4.384416905048769e+19
Gr37_im_4_3 0 s4 x37_im_a3 0 3.4552155978069783e+19
Gr38_re_4_3 0 s4 x38_re_a3 0 -1.556778513159329e+19
Gr38_im_4_3 0 s4 x38_im_a3 0 -8.653039597877095e+18
Gr39_re_4_3 0 s4 x39_re_a3 0 -1.8151800913359393e+18
Gr39_im_4_3 0 s4 x39_im_a3 0 -8.753150415393099e+18
Gr40_re_4_3 0 s4 x40_re_a3 0 -2.3379087105800924e+18
Gr40_im_4_3 0 s4 x40_im_a3 0 1.5896888286088153e+19
Gr41_re_4_3 0 s4 x41_re_a3 0 5.884654967648635e+18
Gr41_im_4_3 0 s4 x41_im_a3 0 -1.2045328506272977e+19
Gr42_re_4_3 0 s4 x42_re_a3 0 -4.0749635559428024e+18
Gr42_im_4_3 0 s4 x42_im_a3 0 6.005193251249367e+18
Gr43_re_4_3 0 s4 x43_re_a3 0 1.2846150273753717e+19
Gr43_im_4_3 0 s4 x43_im_a3 0 1.9455638398394255e+18
Gr44_re_4_3 0 s4 x44_re_a3 0 6.363297415322625e+18
Gr44_im_4_3 0 s4 x44_im_a3 0 -7.440764666424266e+18
Gr45_re_4_3 0 s4 x45_re_a3 0 1.2793251358836259e+19
Gr45_im_4_3 0 s4 x45_im_a3 0 5.260736653242294e+17
Gr46_re_4_3 0 s4 x46_re_a3 0 -1.2864282898194768e+19
Gr46_im_4_3 0 s4 x46_im_a3 0 -7.97739975948312e+18
Gr47_re_4_3 0 s4 x47_re_a3 0 1.0674303783998263e+19
Gr47_im_4_3 0 s4 x47_im_a3 0 -5.037298153727942e+18
Gr48_re_4_3 0 s4 x48_re_a3 0 6.445918030448106e+18
Gr48_im_4_3 0 s4 x48_im_a3 0 -6.544760795460629e+16
Gr49_re_4_3 0 s4 x49_re_a3 0 3.856080596781562e+18
Gr49_im_4_3 0 s4 x49_im_a3 0 1.8579713602398746e+18
Gr50_re_4_3 0 s4 x50_re_a3 0 -1.6691564144191398e+18
Gr50_im_4_3 0 s4 x50_im_a3 0 1.2497988789835615e+18
Gr51_re_4_3 0 s4 x51_re_a3 0 -5.166358175640809e+18
Gr51_im_4_3 0 s4 x51_im_a3 0 6.128699255873844e+17
Gr52_re_4_3 0 s4 x52_re_a3 0 -5.77276998267708e+18
Gr52_im_4_3 0 s4 x52_im_a3 0 4.828902970532808e+17
Gr53_re_4_3 0 s4 x53_re_a3 0 -7.003581961328252e+18
Gr53_im_4_3 0 s4 x53_im_a3 0 2.5008961999424086e+17
Gr54_re_4_3 0 s4 x54_re_a3 0 -7.486424494709353e+18
Gr54_im_4_3 0 s4 x54_im_a3 0 1.7410449646864435e+17
Gr55_re_4_3 0 s4 x55_re_a3 0 -7.723997627312501e+18
Gr55_im_4_3 0 s4 x55_im_a3 0 1.075772748147042e+17
Gr56_re_4_3 0 s4 x56_re_a3 0 -7.224677468350792e+18
Gr56_im_4_3 0 s4 x56_im_a3 0 5.938679566347658e+16
Gr57_re_4_3 0 s4 x57_re_a3 0 -2.360930855343523e+18
Gr57_im_4_3 0 s4 x57_im_a3 0 1.0207024751488066e+16
Gr58_re_4_3 0 s4 x58_re_a3 0 -5.380583653022386e+18
Gr58_im_4_3 0 s4 x58_im_a3 0 2.7904573189986176e+16
Gr59_re_4_3 0 s4 x59_re_a3 0 -1.2567554686293126e+16
Gr59_im_4_3 0 s4 x59_im_a3 0 213921099801065.47
Gr60_re_4_3 0 s4 x60_re_a3 0 -3.979588751130879e+17
Gr60_im_4_3 0 s4 x60_im_a3 0 2358706026363108.5
Gd4_4 0 s4 p4 0 0.0016974503783881026
Fd4_4 0 s4 V4 0.08487251891940513
Gr1_re_4_4 0 s4 x1_re_a4 0 2851887182.817456
Gr1_im_4_4 0 s4 x1_im_a4 0 -4781636015.835255
Gr2_re_4_4 0 s4 x2_re_a4 0 576617940329436.9
Gr2_im_4_4 0 s4 x2_im_a4 0 -445328739515924.56
Gr3_re_4_4 0 s4 x3_re_a4 0 -6748622985041170.0
Gr3_im_4_4 0 s4 x3_im_a4 0 -5506972446187776.0
Gr4_re_4_4 0 s4 x4_re_a4 0 9700753343185108.0
Gr4_im_4_4 0 s4 x4_im_a4 0 2.279737103753608e+16
Gr5_re_4_4 0 s4 x5_re_a4 0 1.0939279538705235e+17
Gr5_im_4_4 0 s4 x5_im_a4 0 -1.8028900568622284e+16
Gr6_re_4_4 0 s4 x6_re_a4 0 8044957233283530.0
Gr6_im_4_4 0 s4 x6_im_a4 0 1.123900165119117e+17
Gr7_re_4_4 0 s4 x7_re_a4 0 1.0645479611349085e+17
Gr7_im_4_4 0 s4 x7_im_a4 0 -2.8042355157021053e+17
Gr8_re_4_4 0 s4 x8_re_a4 0 2.461126152795509e+17
Gr8_im_4_4 0 s4 x8_im_a4 0 -2.2473116456972323e+17
Gr9_re_4_4 0 s4 x9_re_a4 0 -6.533367741449222e+17
Gr9_im_4_4 0 s4 x9_im_a4 0 -4.01434863447709e+16
Gr10_re_4_4 0 s4 x10_re_a4 0 -7.950990855294666e+18
Gr10_im_4_4 0 s4 x10_im_a4 0 -2.613058487735986e+18
Gr11_re_4_4 0 s4 x11_re_a4 0 -2.530978089663372e+18
Gr11_im_4_4 0 s4 x11_im_a4 0 5.49721958582775e+18
Gr12_re_4_4 0 s4 x12_re_a4 0 2.4217782211194073e+19
Gr12_im_4_4 0 s4 x12_im_a4 0 7.626475652509354e+17
Gr13_re_4_4 0 s4 x13_re_a4 0 -6.137116290114733e+18
Gr13_im_4_4 0 s4 x13_im_a4 0 -4.694658012646826e+18
Gr14_re_4_4 0 s4 x14_re_a4 0 -3.6477568789217096e+18
Gr14_im_4_4 0 s4 x14_im_a4 0 8.340974054070954e+17
Gr15_re_4_4 0 s4 x15_re_a4 0 -4.815620401409917e+18
Gr15_im_4_4 0 s4 x15_im_a4 0 -3.19352092489415e+18
Gr16_re_4_4 0 s4 x16_re_a4 0 -1.3708657885686362e+19
Gr16_im_4_4 0 s4 x16_im_a4 0 -7.101379421078269e+18
Gr17_re_4_4 0 s4 x17_re_a4 0 5.340793361780559e+18
Gr17_im_4_4 0 s4 x17_im_a4 0 1.0312504984309891e+19
Gr18_re_4_4 0 s4 x18_re_a4 0 -3.404020621876955e+18
Gr18_im_4_4 0 s4 x18_im_a4 0 1.1288781337746296e+17
Gr19_re_4_4 0 s4 x19_re_a4 0 1.525170321089694e+19
Gr19_im_4_4 0 s4 x19_im_a4 0 8.798235013082049e+18
Gr20_re_4_4 0 s4 x20_re_a4 0 -4.179796013992333e+17
Gr20_im_4_4 0 s4 x20_im_a4 0 2.7254199739061212e+16
Gr21_re_4_4 0 s4 x21_re_a4 0 1.4157181098796644e+19
Gr21_im_4_4 0 s4 x21_im_a4 0 -1.7881179673174587e+18
Gr22_re_4_4 0 s4 x22_re_a4 0 -4.552745265330065e+18
Gr22_im_4_4 0 s4 x22_im_a4 0 -2.791341043247782e+18
Gr23_re_4_4 0 s4 x23_re_a4 0 5.378096854817529e+18
Gr23_im_4_4 0 s4 x23_im_a4 0 -5.198168914347252e+18
Gr24_re_4_4 0 s4 x24_re_a4 0 -9.633033706433853e+18
Gr24_im_4_4 0 s4 x24_im_a4 0 -2.6634898865189418e+17
Gr25_re_4_4 0 s4 x25_re_a4 0 -1.9543270647809654e+17
Gr25_im_4_4 0 s4 x25_im_a4 0 -3.51364683951232e+18
Gr26_re_4_4 0 s4 x26_re_a4 0 -1.506453129500179e+19
Gr26_im_4_4 0 s4 x26_im_a4 0 -5.749097124794106e+18
Gr27_re_4_4 0 s4 x27_re_a4 0 -1.0331731652511213e+18
Gr27_im_4_4 0 s4 x27_im_a4 0 -7.822868951401642e+17
Gr28_re_4_4 0 s4 x28_re_a4 0 -2.4982669218658755e+18
Gr28_im_4_4 0 s4 x28_im_a4 0 3.4455204277681956e+18
Gr29_re_4_4 0 s4 x29_re_a4 0 -7.46122583626413e+18
Gr29_im_4_4 0 s4 x29_im_a4 0 -6.18205637262986e+18
Gr30_re_4_4 0 s4 x30_re_a4 0 -3.4808541616871496e+18
Gr30_im_4_4 0 s4 x30_im_a4 0 1.7073974705021872e+19
Gr31_re_4_4 0 s4 x31_re_a4 0 7.80342882215941e+18
Gr31_im_4_4 0 s4 x31_im_a4 0 2.553389118267613e+18
Gr32_re_4_4 0 s4 x32_re_a4 0 3.335391337832661e+18
Gr32_im_4_4 0 s4 x32_im_a4 0 -2.195180874528475e+18
Gr33_re_4_4 0 s4 x33_re_a4 0 5.970214032936544e+18
Gr33_im_4_4 0 s4 x33_im_a4 0 4.729476233070387e+18
Gr34_re_4_4 0 s4 x34_re_a4 0 9.378572938688098e+18
Gr34_im_4_4 0 s4 x34_im_a4 0 2.2558565592219338e+18
Gr35_re_4_4 0 s4 x35_re_a4 0 3.766277727878305e+18
Gr35_im_4_4 0 s4 x35_im_a4 0 4.869239627126597e+18
Gr36_re_4_4 0 s4 x36_re_a4 0 5.0842223136048136e+16
Gr36_im_4_4 0 s4 x36_im_a4 0 -2.0058028686678705e+18
Gr37_re_4_4 0 s4 x37_re_a4 0 -2.19575738860559e+19
Gr37_im_4_4 0 s4 x37_im_a4 0 -1.7429958864200411e+19
Gr38_re_4_4 0 s4 x38_re_a4 0 7.685671169270728e+18
Gr38_im_4_4 0 s4 x38_im_a4 0 4.183886172659762e+18
Gr39_re_4_4 0 s4 x39_re_a4 0 1.0566778723167297e+18
Gr39_im_4_4 0 s4 x39_im_a4 0 4.1859067205710925e+18
Gr40_re_4_4 0 s4 x40_re_a4 0 1.0960297574616804e+18
Gr40_im_4_4 0 s4 x40_im_a4 0 -7.818903319322112e+18
Gr41_re_4_4 0 s4 x41_re_a4 0 -3.121062754435153e+18
Gr41_im_4_4 0 s4 x41_im_a4 0 5.675673237764876e+18
Gr42_re_4_4 0 s4 x42_re_a4 0 2.1087862945101012e+18
Gr42_im_4_4 0 s4 x42_im_a4 0 -2.6416925642319944e+18
Gr43_re_4_4 0 s4 x43_re_a4 0 -6.323580404311399e+18
Gr43_im_4_4 0 s4 x43_im_a4 0 -7.691075314482563e+17
Gr44_re_4_4 0 s4 x44_re_a4 0 -3.14040461577752e+18
Gr44_im_4_4 0 s4 x44_im_a4 0 3.6631712341906524e+18
Gr45_re_4_4 0 s4 x45_re_a4 0 -6.233032152136692e+18
Gr45_im_4_4 0 s4 x45_im_a4 0 -1.2344985256991436e+16
Gr46_re_4_4 0 s4 x46_re_a4 0 6.332847270935053e+18
Gr46_im_4_4 0 s4 x46_im_a4 0 4.0213999763313393e+18
Gr47_re_4_4 0 s4 x47_re_a4 0 -5.192524827873482e+18
Gr47_im_4_4 0 s4 x47_im_a4 0 2.5961809589223793e+18
Gr48_re_4_4 0 s4 x48_re_a4 0 -3.1053985317225083e+18
Gr48_im_4_4 0 s4 x48_im_a4 0 1.629234495533671e+17
Gr49_re_4_4 0 s4 x49_re_a4 0 -1.8544054141071068e+18
Gr49_im_4_4 0 s4 x49_im_a4 0 -8.161726845771795e+17
Gr50_re_4_4 0 s4 x50_re_a4 0 8.388771008671953e+17
Gr50_im_4_4 0 s4 x50_im_a4 0 -5.6857365114439597e+17
Gr51_re_4_4 0 s4 x51_re_a4 0 2.5469843049290373e+18
Gr51_im_4_4 0 s4 x51_im_a4 0 -2.800259583233231e+17
Gr52_re_4_4 0 s4 x52_re_a4 0 2.845024529753829e+18
Gr52_im_4_4 0 s4 x52_im_a4 0 -2.2031858120658285e+17
Gr53_re_4_4 0 s4 x53_re_a4 0 3.4473934311258194e+18
Gr53_im_4_4 0 s4 x53_im_a4 0 -1.1400084003568139e+17
Gr54_re_4_4 0 s4 x54_re_a4 0 3.6821008623691305e+18
Gr54_im_4_4 0 s4 x54_im_a4 0 -7.946329454288416e+16
Gr55_re_4_4 0 s4 x55_re_a4 0 3.7964218928303995e+18
Gr55_im_4_4 0 s4 x55_im_a4 0 -4.9157105363696456e+16
Gr56_re_4_4 0 s4 x56_re_a4 0 3.5494177929365033e+18
Gr56_im_4_4 0 s4 x56_im_a4 0 -2.715538947243073e+16
Gr57_re_4_4 0 s4 x57_re_a4 0 1.1593780965799647e+18
Gr57_im_4_4 0 s4 x57_im_a4 0 -4670035485964325.0
Gr58_re_4_4 0 s4 x58_re_a4 0 2.64269754224858e+18
Gr58_im_4_4 0 s4 x58_im_a4 0 -1.276542803164446e+16
Gr59_re_4_4 0 s4 x59_re_a4 0 6170518692622780.0
Gr59_im_4_4 0 s4 x59_im_a4 0 -97925929043717.61
Gr60_re_4_4 0 s4 x60_re_a4 0 1.9540688856749392e+17
Gr60_im_4_4 0 s4 x60_im_a4 0 -1079263213113213.5
*
* State networks driven by port 4
Cx1_re_a4 x1_re_a4 0 1.0
Gx1_re_a4 0 x1_re_a4 p4 0 0.1414213562373095
Fx1_re_a4 0 x1_re_a4 V4 7.0710678118654755
Rp1_re_re_a4 0 x1_re_a4 1.9339271087549648e-10
Gp1_re_im_a4 0 x1_re_a4 x1_im_a4 0 347079283315.0595
Cx1_im_a4 x1_im_a4 0 1.0
Gp1_im_re_a4 0 x1_im_a4 x1_re_a4 0 -347079283315.0595
Rp1_im_im_a4 0 x1_im_a4 1.9339271087549648e-10
Cx2_re_a4 x2_re_a4 0 1.0
Gx2_re_a4 0 x2_re_a4 p4 0 0.1414213562373095
Fx2_re_a4 0 x2_re_a4 V4 7.0710678118654755
Rp2_re_re_a4 0 x2_re_a4 5.691004706881973e-10
Gp2_re_im_a4 0 x2_re_a4 x2_im_a4 0 303418375537.5658
Cx2_im_a4 x2_im_a4 0 1.0
Gp2_im_re_a4 0 x2_im_a4 x2_re_a4 0 -303418375537.5658
Rp2_im_im_a4 0 x2_im_a4 5.691004706881973e-10
Cx3_re_a4 x3_re_a4 0 1.0
Gx3_re_a4 0 x3_re_a4 p4 0 0.1414213562373095
Fx3_re_a4 0 x3_re_a4 V4 7.0710678118654755
Rp3_re_re_a4 0 x3_re_a4 5.362465275255059e-10
Gp3_re_im_a4 0 x3_re_a4 x3_im_a4 0 299764945822.76807
Cx3_im_a4 x3_im_a4 0 1.0
Gp3_im_re_a4 0 x3_im_a4 x3_re_a4 0 -299764945822.76807
Rp3_im_im_a4 0 x3_im_a4 5.362465275255059e-10
Cx4_re_a4 x4_re_a4 0 1.0
Gx4_re_a4 0 x4_re_a4 p4 0 0.1414213562373095
Fx4_re_a4 0 x4_re_a4 V4 7.0710678118654755
Rp4_re_re_a4 0 x4_re_a4 5.651020630265948e-10
Gp4_re_im_a4 0 x4_re_a4 x4_im_a4 0 295780770455.4801
Cx4_im_a4 x4_im_a4 0 1.0
Gp4_im_re_a4 0 x4_im_a4 x4_re_a4 0 -295780770455.4801
Rp4_im_im_a4 0 x4_im_a4 5.651020630265948e-10
Cx5_re_a4 x5_re_a4 0 1.0
Gx5_re_a4 0 x5_re_a4 p4 0 0.1414213562373095
Fx5_re_a4 0 x5_re_a4 V4 7.0710678118654755
Rp5_re_re_a4 0 x5_re_a4 4.4583648371353355e-11
Gp5_re_im_a4 0 x5_re_a4 x5_im_a4 0 280184551048.1205
Cx5_im_a4 x5_im_a4 0 1.0
Gp5_im_re_a4 0 x5_im_a4 x5_re_a4 0 -280184551048.1205
Rp5_im_im_a4 0 x5_im_a4 4.4583648371353355e-11
Cx6_re_a4 x6_re_a4 0 1.0
Gx6_re_a4 0 x6_re_a4 p4 0 0.1414213562373095
Fx6_re_a4 0 x6_re_a4 V4 7.0710678118654755
Rp6_re_re_a4 0 x6_re_a4 9.027710283976132e-10
Gp6_re_im_a4 0 x6_re_a4 x6_im_a4 0 284797609898.4314
Cx6_im_a4 x6_im_a4 0 1.0
Gp6_im_re_a4 0 x6_im_a4 x6_re_a4 0 -284797609898.4314
Rp6_im_im_a4 0 x6_im_a4 9.027710283976132e-10
Cx7_re_a4 x7_re_a4 0 1.0
Gx7_re_a4 0 x7_re_a4 p4 0 0.1414213562373095
Fx7_re_a4 0 x7_re_a4 V4 7.0710678118654755
Rp7_re_re_a4 0 x7_re_a4 7.771258315741444e-10
Gp7_re_im_a4 0 x7_re_a4 x7_im_a4 0 280937443543.525
Cx7_im_a4 x7_im_a4 0 1.0
Gp7_im_re_a4 0 x7_im_a4 x7_re_a4 0 -280937443543.525
Rp7_im_im_a4 0 x7_im_a4 7.771258315741444e-10
Cx8_re_a4 x8_re_a4 0 1.0
Gx8_re_a4 0 x8_re_a4 p4 0 0.1414213562373095
Fx8_re_a4 0 x8_re_a4 V4 7.0710678118654755
Rp8_re_re_a4 0 x8_re_a4 1.3252660304487296e-09
Gp8_re_im_a4 0 x8_re_a4 x8_im_a4 0 269390760843.16248
Cx8_im_a4 x8_im_a4 0 1.0
Gp8_im_re_a4 0 x8_im_a4 x8_re_a4 0 -269390760843.16248
Rp8_im_im_a4 0 x8_im_a4 1.3252660304487296e-09
Cx9_re_a4 x9_re_a4 0 1.0
Gx9_re_a4 0 x9_re_a4 p4 0 0.1414213562373095
Fx9_re_a4 0 x9_re_a4 V4 7.0710678118654755
Rp9_re_re_a4 0 x9_re_a4 8.837487410164448e-10
Gp9_re_im_a4 0 x9_re_a4 x9_im_a4 0 260736146261.56058
Cx9_im_a4 x9_im_a4 0 1.0
Gp9_im_re_a4 0 x9_im_a4 x9_re_a4 0 -260736146261.56058
Rp9_im_im_a4 0 x9_im_a4 8.837487410164448e-10
Cx10_re_a4 x10_re_a4 0 1.0
Gx10_re_a4 0 x10_re_a4 p4 0 0.1414213562373095
Fx10_re_a4 0 x10_re_a4 V4 7.0710678118654755
Rp10_re_re_a4 0 x10_re_a4 7.74337520639369e-10
Gp10_re_im_a4 0 x10_re_a4 x10_im_a4 0 246291422182.96008
Cx10_im_a4 x10_im_a4 0 1.0
Gp10_im_re_a4 0 x10_im_a4 x10_re_a4 0 -246291422182.96008
Rp10_im_im_a4 0 x10_im_a4 7.74337520639369e-10
Cx11_re_a4 x11_re_a4 0 1.0
Gx11_re_a4 0 x11_re_a4 p4 0 0.1414213562373095
Fx11_re_a4 0 x11_re_a4 V4 7.0710678118654755
Rp11_re_re_a4 0 x11_re_a4 8.390860458298588e-10
Gp11_re_im_a4 0 x11_re_a4 x11_im_a4 0 242228737451.13144
Cx11_im_a4 x11_im_a4 0 1.0
Gp11_im_re_a4 0 x11_im_a4 x11_re_a4 0 -242228737451.13144
Rp11_im_im_a4 0 x11_im_a4 8.390860458298588e-10
Cx12_re_a4 x12_re_a4 0 1.0
Gx12_re_a4 0 x12_re_a4 p4 0 0.1414213562373095
Fx12_re_a4 0 x12_re_a4 V4 7.0710678118654755
Rp12_re_re_a4 0 x12_re_a4 4.4656692854153325e-10
Gp12_re_im_a4 0 x12_re_a4 x12_im_a4 0 236640156802.20322
Cx12_im_a4 x12_im_a4 0 1.0
Gp12_im_re_a4 0 x12_im_a4 x12_re_a4 0 -236640156802.20322
Rp12_im_im_a4 0 x12_im_a4 4.4656692854153325e-10
Cx13_re_a4 x13_re_a4 0 1.0
Gx13_re_a4 0 x13_re_a4 p4 0 0.1414213562373095
Fx13_re_a4 0 x13_re_a4 V4 7.0710678118654755
Rp13_re_re_a4 0 x13_re_a4 6.602787100602715e-10
Gp13_re_im_a4 0 x13_re_a4 x13_im_a4 0 229310531843.11926
Cx13_im_a4 x13_im_a4 0 1.0
Gp13_im_re_a4 0 x13_im_a4 x13_re_a4 0 -229310531843.11926
Rp13_im_im_a4 0 x13_im_a4 6.602787100602715e-10
Cx14_re_a4 x14_re_a4 0 1.0
Gx14_re_a4 0 x14_re_a4 p4 0 0.1414213562373095
Fx14_re_a4 0 x14_re_a4 V4 7.0710678118654755
Rp14_re_re_a4 0 x14_re_a4 6.683832237932593e-10
Gp14_re_im_a4 0 x14_re_a4 x14_im_a4 0 221343536942.1764
Cx14_im_a4 x14_im_a4 0 1.0
Gp14_im_re_a4 0 x14_im_a4 x14_re_a4 0 -221343536942.1764
Rp14_im_im_a4 0 x14_im_a4 6.683832237932593e-10
Cx15_re_a4 x15_re_a4 0 1.0
Gx15_re_a4 0 x15_re_a4 p4 0 0.1414213562373095
Fx15_re_a4 0 x15_re_a4 V4 7.0710678118654755
Rp15_re_re_a4 0 x15_re_a4 7.821256797324849e-10
Gp15_re_im_a4 0 x15_re_a4 x15_im_a4 0 216900169045.56696
Cx15_im_a4 x15_im_a4 0 1.0
Gp15_im_re_a4 0 x15_im_a4 x15_re_a4 0 -216900169045.56696
Rp15_im_im_a4 0 x15_im_a4 7.821256797324849e-10
Cx16_re_a4 x16_re_a4 0 1.0
Gx16_re_a4 0 x16_re_a4 p4 0 0.1414213562373095
Fx16_re_a4 0 x16_re_a4 V4 7.0710678118654755
Rp16_re_re_a4 0 x16_re_a4 7.830440984431804e-10
Gp16_re_im_a4 0 x16_re_a4 x16_im_a4 0 205989675376.3724
Cx16_im_a4 x16_im_a4 0 1.0
Gp16_im_re_a4 0 x16_im_a4 x16_re_a4 0 -205989675376.3724
Rp16_im_im_a4 0 x16_im_a4 7.830440984431804e-10
Cx17_re_a4 x17_re_a4 0 1.0
Gx17_re_a4 0 x17_re_a4 p4 0 0.1414213562373095
Fx17_re_a4 0 x17_re_a4 V4 7.0710678118654755
Rp17_re_re_a4 0 x17_re_a4 3.6596596885047425e-10
Gp17_re_im_a4 0 x17_re_a4 x17_im_a4 0 200356736984.54144
Cx17_im_a4 x17_im_a4 0 1.0
Gp17_im_re_a4 0 x17_im_a4 x17_re_a4 0 -200356736984.54144
Rp17_im_im_a4 0 x17_im_a4 3.6596596885047425e-10
Cx18_re_a4 x18_re_a4 0 1.0
Gx18_re_a4 0 x18_re_a4 p4 0 0.1414213562373095
Fx18_re_a4 0 x18_re_a4 V4 7.0710678118654755
Rp18_re_re_a4 0 x18_re_a4 4.584479098871507e-10
Gp18_re_im_a4 0 x18_re_a4 x18_im_a4 0 194828352286.79108
Cx18_im_a4 x18_im_a4 0 1.0
Gp18_im_re_a4 0 x18_im_a4 x18_re_a4 0 -194828352286.79108
Rp18_im_im_a4 0 x18_im_a4 4.584479098871507e-10
Cx19_re_a4 x19_re_a4 0 1.0
Gx19_re_a4 0 x19_re_a4 p4 0 0.1414213562373095
Fx19_re_a4 0 x19_re_a4 V4 7.0710678118654755
Rp19_re_re_a4 0 x19_re_a4 3.2577500493070084e-10
Gp19_re_im_a4 0 x19_re_a4 x19_im_a4 0 187933840477.96106
Cx19_im_a4 x19_im_a4 0 1.0
Gp19_im_re_a4 0 x19_im_a4 x19_re_a4 0 -187933840477.96106
Rp19_im_im_a4 0 x19_im_a4 3.2577500493070084e-10
Cx20_re_a4 x20_re_a4 0 1.0
Gx20_re_a4 0 x20_re_a4 p4 0 0.1414213562373095
Fx20_re_a4 0 x20_re_a4 V4 7.0710678118654755
Rp20_re_re_a4 0 x20_re_a4 3.7030670747264964e-10
Gp20_re_im_a4 0 x20_re_a4 x20_im_a4 0 182988642847.68027
Cx20_im_a4 x20_im_a4 0 1.0
Gp20_im_re_a4 0 x20_im_a4 x20_re_a4 0 -182988642847.68027
Rp20_im_im_a4 0 x20_im_a4 3.7030670747264964e-10
Cx21_re_a4 x21_re_a4 0 1.0
Gx21_re_a4 0 x21_re_a4 p4 0 0.1414213562373095
Fx21_re_a4 0 x21_re_a4 V4 7.0710678118654755
Rp21_re_re_a4 0 x21_re_a4 4.088062182753204e-10
Gp21_re_im_a4 0 x21_re_a4 x21_im_a4 0 177633712933.48953
Cx21_im_a4 x21_im_a4 0 1.0
Gp21_im_re_a4 0 x21_im_a4 x21_re_a4 0 -177633712933.48953
Rp21_im_im_a4 0 x21_im_a4 4.088062182753204e-10
Cx22_re_a4 x22_re_a4 0 1.0
Gx22_re_a4 0 x22_re_a4 p4 0 0.1414213562373095
Fx22_re_a4 0 x22_re_a4 V4 7.0710678118654755
Rp22_re_re_a4 0 x22_re_a4 3.9909194915050626e-10
Gp22_re_im_a4 0 x22_re_a4 x22_im_a4 0 170516011194.32175
Cx22_im_a4 x22_im_a4 0 1.0
Gp22_im_re_a4 0 x22_im_a4 x22_re_a4 0 -170516011194.32175
Rp22_im_im_a4 0 x22_im_a4 3.9909194915050626e-10
Cx23_re_a4 x23_re_a4 0 1.0
Gx23_re_a4 0 x23_re_a4 p4 0 0.1414213562373095
Fx23_re_a4 0 x23_re_a4 V4 7.0710678118654755
Rp23_re_re_a4 0 x23_re_a4 3.5380163711038947e-10
Gp23_re_im_a4 0 x23_re_a4 x23_im_a4 0 164953816321.0323
Cx23_im_a4 x23_im_a4 0 1.0
Gp23_im_re_a4 0 x23_im_a4 x23_re_a4 0 -164953816321.0323
Rp23_im_im_a4 0 x23_im_a4 3.5380163711038947e-10
Cx24_re_a4 x24_re_a4 0 1.0
Gx24_re_a4 0 x24_re_a4 p4 0 0.1414213562373095
Fx24_re_a4 0 x24_re_a4 V4 7.0710678118654755
Rp24_re_re_a4 0 x24_re_a4 5.039130565519937e-10
Gp24_re_im_a4 0 x24_re_a4 x24_im_a4 0 159173864190.63727
Cx24_im_a4 x24_im_a4 0 1.0
Gp24_im_re_a4 0 x24_im_a4 x24_re_a4 0 -159173864190.63727
Rp24_im_im_a4 0 x24_im_a4 5.039130565519937e-10
Cx25_re_a4 x25_re_a4 0 1.0
Gx25_re_a4 0 x25_re_a4 p4 0 0.1414213562373095
Fx25_re_a4 0 x25_re_a4 V4 7.0710678118654755
Rp25_re_re_a4 0 x25_re_a4 4.289339569151169e-10
Gp25_re_im_a4 0 x25_re_a4 x25_im_a4 0 152473894102.3021
Cx25_im_a4 x25_im_a4 0 1.0
Gp25_im_re_a4 0 x25_im_a4 x25_re_a4 0 -152473894102.3021
Rp25_im_im_a4 0 x25_im_a4 4.289339569151169e-10
Cx26_re_a4 x26_re_a4 0 1.0
Gx26_re_a4 0 x26_re_a4 p4 0 0.1414213562373095
Fx26_re_a4 0 x26_re_a4 V4 7.0710678118654755
Rp26_re_re_a4 0 x26_re_a4 5.604106708721165e-10
Gp26_re_im_a4 0 x26_re_a4 x26_im_a4 0 143458007374.04828
Cx26_im_a4 x26_im_a4 0 1.0
Gp26_im_re_a4 0 x26_im_a4 x26_re_a4 0 -143458007374.04828
Rp26_im_im_a4 0 x26_im_a4 5.604106708721165e-10
Cx27_re_a4 x27_re_a4 0 1.0
Gx27_re_a4 0 x27_re_a4 p4 0 0.1414213562373095
Fx27_re_a4 0 x27_re_a4 V4 7.0710678118654755
Rp27_re_re_a4 0 x27_re_a4 4.0415824417463693e-10
Gp27_re_im_a4 0 x27_re_a4 x27_im_a4 0 139191009718.3968
Cx27_im_a4 x27_im_a4 0 1.0
Gp27_im_re_a4 0 x27_im_a4 x27_re_a4 0 -139191009718.3968
Rp27_im_im_a4 0 x27_im_a4 4.0415824417463693e-10
Cx28_re_a4 x28_re_a4 0 1.0
Gx28_re_a4 0 x28_re_a4 p4 0 0.1414213562373095
Fx28_re_a4 0 x28_re_a4 V4 7.0710678118654755
Rp28_re_re_a4 0 x28_re_a4 5.515497777837109e-10
Gp28_re_im_a4 0 x28_re_a4 x28_im_a4 0 135717785993.89098
Cx28_im_a4 x28_im_a4 0 1.0
Gp28_im_re_a4 0 x28_im_a4 x28_re_a4 0 -135717785993.89098
Rp28_im_im_a4 0 x28_im_a4 5.515497777837109e-10
Cx29_re_a4 x29_re_a4 0 1.0
Gx29_re_a4 0 x29_re_a4 p4 0 0.1414213562373095
Fx29_re_a4 0 x29_re_a4 V4 7.0710678118654755
Rp29_re_re_a4 0 x29_re_a4 5.385911467068673e-10
Gp29_re_im_a4 0 x29_re_a4 x29_im_a4 0 130198859531.93167
Cx29_im_a4 x29_im_a4 0 1.0
Gp29_im_re_a4 0 x29_im_a4 x29_re_a4 0 -130198859531.93167
Rp29_im_im_a4 0 x29_im_a4 5.385911467068673e-10
Cx30_re_a4 x30_re_a4 0 1.0
Gx30_re_a4 0 x30_re_a4 p4 0 0.1414213562373095
Fx30_re_a4 0 x30_re_a4 V4 7.0710678118654755
Rp30_re_re_a4 0 x30_re_a4 1.293631499869189e-10
Gp30_re_im_a4 0 x30_re_a4 x30_im_a4 0 125026933526.9245
Cx30_im_a4 x30_im_a4 0 1.0
Gp30_im_re_a4 0 x30_im_a4 x30_re_a4 0 -125026933526.9245
Rp30_im_im_a4 0 x30_im_a4 1.293631499869189e-10
Cx31_re_a4 x31_re_a4 0 1.0
Gx31_re_a4 0 x31_re_a4 p4 0 0.1414213562373095
Fx31_re_a4 0 x31_re_a4 V4 7.0710678118654755
Rp31_re_re_a4 0 x31_re_a4 4.4598309986159816e-10
Gp31_re_im_a4 0 x31_re_a4 x31_im_a4 0 125249512856.41823
Cx31_im_a4 x31_im_a4 0 1.0
Gp31_im_re_a4 0 x31_im_a4 x31_re_a4 0 -125249512856.41823
Rp31_im_im_a4 0 x31_im_a4 4.4598309986159816e-10
Cx32_re_a4 x32_re_a4 0 1.0
Gx32_re_a4 0 x32_re_a4 p4 0 0.1414213562373095
Fx32_re_a4 0 x32_re_a4 V4 7.0710678118654755
Rp32_re_re_a4 0 x32_re_a4 6.806449337893251e-10
Gp32_re_im_a4 0 x32_re_a4 x32_im_a4 0 114377525421.56393
Cx32_im_a4 x32_im_a4 0 1.0
Gp32_im_re_a4 0 x32_im_a4 x32_re_a4 0 -114377525421.56393
Rp32_im_im_a4 0 x32_im_a4 6.806449337893251e-10
Cx33_re_a4 x33_re_a4 0 1.0
Gx33_re_a4 0 x33_re_a4 p4 0 0.1414213562373095
Fx33_re_a4 0 x33_re_a4 V4 7.0710678118654755
Rp33_re_re_a4 0 x33_re_a4 6.827975557481133e-10
Gp33_re_im_a4 0 x33_re_a4 x33_im_a4 0 109880322668.63147
Cx33_im_a4 x33_im_a4 0 1.0
Gp33_im_re_a4 0 x33_im_a4 x33_re_a4 0 -109880322668.63147
Rp33_im_im_a4 0 x33_im_a4 6.827975557481133e-10
Cx34_re_a4 x34_re_a4 0 1.0
Gx34_re_a4 0 x34_re_a4 p4 0 0.1414213562373095
Fx34_re_a4 0 x34_re_a4 V4 7.0710678118654755
Rp34_re_re_a4 0 x34_re_a4 6.414613283370872e-10
Gp34_re_im_a4 0 x34_re_a4 x34_im_a4 0 100363561795.05267
Cx34_im_a4 x34_im_a4 0 1.0
Gp34_im_re_a4 0 x34_im_a4 x34_re_a4 0 -100363561795.05267
Rp34_im_im_a4 0 x34_im_a4 6.414613283370872e-10
Cx35_re_a4 x35_re_a4 0 1.0
Gx35_re_a4 0 x35_re_a4 p4 0 0.1414213562373095
Fx35_re_a4 0 x35_re_a4 V4 7.0710678118654755
Rp35_re_re_a4 0 x35_re_a4 5.255745869778509e-10
Gp35_re_im_a4 0 x35_re_a4 x35_im_a4 0 95922025504.53201
Cx35_im_a4 x35_im_a4 0 1.0
Gp35_im_re_a4 0 x35_im_a4 x35_re_a4 0 -95922025504.53201
Rp35_im_im_a4 0 x35_im_a4 5.255745869778509e-10
Cx36_re_a4 x36_re_a4 0 1.0
Gx36_re_a4 0 x36_re_a4 p4 0 0.1414213562373095
Fx36_re_a4 0 x36_re_a4 V4 7.0710678118654755
Rp36_re_re_a4 0 x36_re_a4 4.701845418472811e-10
Gp36_re_im_a4 0 x36_re_a4 x36_im_a4 0 91827204426.0559
Cx36_im_a4 x36_im_a4 0 1.0
Gp36_im_re_a4 0 x36_im_a4 x36_re_a4 0 -91827204426.0559
Rp36_im_im_a4 0 x36_im_a4 4.701845418472811e-10
Cx37_re_a4 x37_re_a4 0 1.0
Gx37_re_a4 0 x37_re_a4 p4 0 0.1414213562373095
Fx37_re_a4 0 x37_re_a4 V4 7.0710678118654755
Rp37_re_re_a4 0 x37_re_a4 5.1986573840207194e-11
Gp37_re_im_a4 0 x37_re_a4 x37_im_a4 0 72397845044.52003
Cx37_im_a4 x37_im_a4 0 1.0
Gp37_im_re_a4 0 x37_im_a4 x37_re_a4 0 -72397845044.52003
Rp37_im_im_a4 0 x37_im_a4 5.1986573840207194e-11
Cx38_re_a4 x38_re_a4 0 1.0
Gx38_re_a4 0 x38_re_a4 p4 0 0.1414213562373095
Fx38_re_a4 0 x38_re_a4 V4 7.0710678118654755
Rp38_re_re_a4 0 x38_re_a4 6.266691087283841e-10
Gp38_re_im_a4 0 x38_re_a4 x38_im_a4 0 87242951630.81523
Cx38_im_a4 x38_im_a4 0 1.0
Gp38_im_re_a4 0 x38_im_a4 x38_re_a4 0 -87242951630.81523
Rp38_im_im_a4 0 x38_im_a4 6.266691087283841e-10
Cx39_re_a4 x39_re_a4 0 1.0
Gx39_re_a4 0 x39_re_a4 p4 0 0.1414213562373095
Fx39_re_a4 0 x39_re_a4 V4 7.0710678118654755
Rp39_re_re_a4 0 x39_re_a4 5.234864343640884e-10
Gp39_re_im_a4 0 x39_re_a4 x39_im_a4 0 82858757195.85092
Cx39_im_a4 x39_im_a4 0 1.0
Gp39_im_re_a4 0 x39_im_a4 x39_re_a4 0 -82858757195.85092
Rp39_im_im_a4 0 x39_im_a4 5.234864343640884e-10
Cx40_re_a4 x40_re_a4 0 1.0
Gx40_re_a4 0 x40_re_a4 p4 0 0.1414213562373095
Fx40_re_a4 0 x40_re_a4 V4 7.0710678118654755
Rp40_re_re_a4 0 x40_re_a4 5.871156006436874e-10
Gp40_re_im_a4 0 x40_re_a4 x40_im_a4 0 78507674910.57098
Cx40_im_a4 x40_im_a4 0 1.0
Gp40_im_re_a4 0 x40_im_a4 x40_re_a4 0 -78507674910.57098
Rp40_im_im_a4 0 x40_im_a4 5.871156006436874e-10
Cx41_re_a4 x41_re_a4 0 1.0
Gx41_re_a4 0 x41_re_a4 p4 0 0.1414213562373095
Fx41_re_a4 0 x41_re_a4 V4 7.0710678118654755
Rp41_re_re_a4 0 x41_re_a4 7.362920812502898e-10
Gp41_re_im_a4 0 x41_re_a4 x41_im_a4 0 53898762948.71844
Cx41_im_a4 x41_im_a4 0 1.0
Gp41_im_re_a4 0 x41_im_a4 x41_re_a4 0 -53898762948.71844
Rp41_im_im_a4 0 x41_im_a4 7.362920812502898e-10
Cx42_re_a4 x42_re_a4 0 1.0
Gx42_re_a4 0 x42_re_a4 p4 0 0.1414213562373095
Fx42_re_a4 0 x42_re_a4 V4 7.0710678118654755
Rp42_re_re_a4 0 x42_re_a4 6.83072510187094e-10
Gp42_re_im_a4 0 x42_re_a4 x42_im_a4 0 49596203552.090675
Cx42_im_a4 x42_im_a4 0 1.0
Gp42_im_re_a4 0 x42_im_a4 x42_re_a4 0 -49596203552.090675
Rp42_im_im_a4 0 x42_im_a4 6.83072510187094e-10
Cx43_re_a4 x43_re_a4 0 1.0
Gx43_re_a4 0 x43_re_a4 p4 0 0.1414213562373095
Fx43_re_a4 0 x43_re_a4 V4 7.0710678118654755
Rp43_re_re_a4 0 x43_re_a4 7.886851854703573e-10
Gp43_re_im_a4 0 x43_re_a4 x43_im_a4 0 33914448806.74464
Cx43_im_a4 x43_im_a4 0 1.0
Gp43_im_re_a4 0 x43_im_a4 x43_re_a4 0 -33914448806.74464
Rp43_im_im_a4 0 x43_im_a4 7.886851854703573e-10
Cx44_re_a4 x44_re_a4 0 1.0
Gx44_re_a4 0 x44_re_a4 p4 0 0.1414213562373095
Fx44_re_a4 0 x44_re_a4 V4 7.0710678118654755
Rp44_re_re_a4 0 x44_re_a4 6.90773635036418e-10
Gp44_re_im_a4 0 x44_re_a4 x44_im_a4 0 28461055845.680824
Cx44_im_a4 x44_im_a4 0 1.0
Gp44_im_re_a4 0 x44_im_a4 x44_re_a4 0 -28461055845.680824
Rp44_im_im_a4 0 x44_im_a4 6.90773635036418e-10
Cx45_re_a4 x45_re_a4 0 1.0
Gx45_re_a4 0 x45_re_a4 p4 0 0.1414213562373095
Fx45_re_a4 0 x45_re_a4 V4 7.0710678118654755
Rp45_re_re_a4 0 x45_re_a4 6.80191910067349e-10
Gp45_re_im_a4 0 x45_re_a4 x45_im_a4 0 24097859368.009228
Cx45_im_a4 x45_im_a4 0 1.0
Gp45_im_re_a4 0 x45_im_a4 x45_re_a4 0 -24097859368.009228
Rp45_im_im_a4 0 x45_im_a4 6.80191910067349e-10
Cx46_re_a4 x46_re_a4 0 1.0
Gx46_re_a4 0 x46_re_a4 p4 0 0.1414213562373095
Fx46_re_a4 0 x46_re_a4 V4 7.0710678118654755
Rp46_re_re_a4 0 x46_re_a4 3.3632515940909853e-10
Gp46_re_im_a4 0 x46_re_a4 x46_im_a4 0 17535003925.97815
Cx46_im_a4 x46_im_a4 0 1.0
Gp46_im_re_a4 0 x46_im_a4 x46_re_a4 0 -17535003925.97815
Rp46_im_im_a4 0 x46_im_a4 3.3632515940909853e-10
Cx47_re_a4 x47_re_a4 0 1.0
Gx47_re_a4 0 x47_re_a4 p4 0 0.1414213562373095
Fx47_re_a4 0 x47_re_a4 V4 7.0710678118654755
Rp47_re_re_a4 0 x47_re_a4 9.629414892146456e-10
Gp47_re_im_a4 0 x47_re_a4 x47_im_a4 0 11715090574.045237
Cx47_im_a4 x47_im_a4 0 1.0
Gp47_im_re_a4 0 x47_im_a4 x47_re_a4 0 -11715090574.045237
Rp47_im_im_a4 0 x47_im_a4 9.629414892146456e-10
Cx48_re_a4 x48_re_a4 0 1.0
Gx48_re_a4 0 x48_re_a4 p4 0 0.1414213562373095
Fx48_re_a4 0 x48_re_a4 V4 7.0710678118654755
Rp48_re_re_a4 0 x48_re_a4 8.037389283921146e-10
Gp48_re_im_a4 0 x48_re_a4 x48_im_a4 0 8411555387.1175995
Cx48_im_a4 x48_im_a4 0 1.0
Gp48_im_re_a4 0 x48_im_a4 x48_re_a4 0 -8411555387.1175995
Rp48_im_im_a4 0 x48_im_a4 8.037389283921146e-10
Cx49_re_a4 x49_re_a4 0 1.0
Gx49_re_a4 0 x49_re_a4 p4 0 0.1414213562373095
Fx49_re_a4 0 x49_re_a4 V4 7.0710678118654755
Rp49_re_re_a4 0 x49_re_a4 2.3953032926638584e-09
Gp49_re_im_a4 0 x49_re_a4 x49_im_a4 0 7281971191.968741
Cx49_im_a4 x49_im_a4 0 1.0
Gp49_im_re_a4 0 x49_im_a4 x49_re_a4 0 -7281971191.968741
Rp49_im_im_a4 0 x49_im_a4 2.3953032926638584e-09
Cx50_re_a4 x50_re_a4 0 1.0
Gx50_re_a4 0 x50_re_a4 p4 0 0.1414213562373095
Fx50_re_a4 0 x50_re_a4 V4 7.0710678118654755
Rp50_re_re_a4 0 x50_re_a4 9.291538099627055e-09
Gp50_re_im_a4 0 x50_re_a4 x50_im_a4 0 5485192888.061847
Cx50_im_a4 x50_im_a4 0 1.0
Gp50_im_re_a4 0 x50_im_a4 x50_re_a4 0 -5485192888.061847
Rp50_im_im_a4 0 x50_im_a4 9.291538099627055e-09
Cx51_re_a4 x51_re_a4 0 1.0
Gx51_re_a4 0 x51_re_a4 p4 0 0.1414213562373095
Fx51_re_a4 0 x51_re_a4 V4 7.0710678118654755
Rp51_re_re_a4 0 x51_re_a4 1.1361341983747998e-08
Gp51_re_im_a4 0 x51_re_a4 x51_im_a4 0 4208225203.7586317
Cx51_im_a4 x51_im_a4 0 1.0
Gp51_im_re_a4 0 x51_im_a4 x51_re_a4 0 -4208225203.7586317
Rp51_im_im_a4 0 x51_im_a4 1.1361341983747998e-08
Cx52_re_a4 x52_re_a4 0 1.0
Gx52_re_a4 0 x52_re_a4 p4 0 0.1414213562373095
Fx52_re_a4 0 x52_re_a4 V4 7.0710678118654755
Rp52_re_re_a4 0 x52_re_a4 6.593416593325721e-09
Gp52_re_im_a4 0 x52_re_a4 x52_im_a4 0 3907713961.770896
Cx52_im_a4 x52_im_a4 0 1.0
Gp52_im_re_a4 0 x52_im_a4 x52_re_a4 0 -3907713961.770896
Rp52_im_im_a4 0 x52_im_a4 6.593416593325721e-09
Cx53_re_a4 x53_re_a4 0 1.0
Gx53_re_a4 0 x53_re_a4 p4 0 0.1414213562373095
Fx53_re_a4 0 x53_re_a4 V4 7.0710678118654755
Rp53_re_re_a4 0 x53_re_a4 4.598865760619702e-09
Gp53_re_im_a4 0 x53_re_a4 x53_im_a4 0 3138989640.311349
Cx53_im_a4 x53_im_a4 0 1.0
Gp53_im_re_a4 0 x53_im_a4 x53_re_a4 0 -3138989640.311349
Rp53_im_im_a4 0 x53_im_a4 4.598865760619702e-09
Cx54_re_a4 x54_re_a4 0 1.0
Gx54_re_a4 0 x54_re_a4 p4 0 0.1414213562373095
Fx54_re_a4 0 x54_re_a4 V4 7.0710678118654755
Rp54_re_re_a4 0 x54_re_a4 5.013329113974378e-09
Gp54_re_im_a4 0 x54_re_a4 x54_im_a4 0 2763239017.283009
Cx54_im_a4 x54_im_a4 0 1.0
Gp54_im_re_a4 0 x54_im_a4 x54_re_a4 0 -2763239017.283009
Rp54_im_im_a4 0 x54_im_a4 5.013329113974378e-09
Cx55_re_a4 x55_re_a4 0 1.0
Gx55_re_a4 0 x55_re_a4 p4 0 0.1414213562373095
Fx55_re_a4 0 x55_re_a4 V4 7.0710678118654755
Rp55_re_re_a4 0 x55_re_a4 5.489391819401233e-09
Gp55_re_im_a4 0 x55_re_a4 x55_im_a4 0 2337692824.826442
Cx55_im_a4 x55_im_a4 0 1.0
Gp55_im_re_a4 0 x55_im_a4 x55_re_a4 0 -2337692824.826442
Rp55_im_im_a4 0 x55_im_a4 5.489391819401233e-09
Cx56_re_a4 x56_re_a4 0 1.0
Gx56_re_a4 0 x56_re_a4 p4 0 0.1414213562373095
Fx56_re_a4 0 x56_re_a4 V4 7.0710678118654755
Rp56_re_re_a4 0 x56_re_a4 5.715836849677958e-09
Gp56_re_im_a4 0 x56_re_a4 x56_im_a4 0 1907462400.4905782
Cx56_im_a4 x56_im_a4 0 1.0
Gp56_im_re_a4 0 x56_im_a4 x56_re_a4 0 -1907462400.4905782
Rp56_im_im_a4 0 x56_im_a4 5.715836849677958e-09
Cx57_re_a4 x57_re_a4 0 1.0
Gx57_re_a4 0 x57_re_a4 p4 0 0.1414213562373095
Fx57_re_a4 0 x57_re_a4 V4 7.0710678118654755
Rp57_re_re_a4 0 x57_re_a4 5.740354751724126e-09
Gp57_re_im_a4 0 x57_re_a4 x57_im_a4 0 1043629713.8561413
Cx57_im_a4 x57_im_a4 0 1.0
Gp57_im_re_a4 0 x57_im_a4 x57_re_a4 0 -1043629713.8561413
Rp57_im_im_a4 0 x57_im_a4 5.740354751724126e-09
Cx58_re_a4 x58_re_a4 0 1.0
Gx58_re_a4 0 x58_re_a4 p4 0 0.1414213562373095
Fx58_re_a4 0 x58_re_a4 V4 7.0710678118654755
Rp58_re_re_a4 0 x58_re_a4 5.783268392817006e-09
Gp58_re_im_a4 0 x58_re_a4 x58_im_a4 0 1474144465.2759433
Cx58_im_a4 x58_im_a4 0 1.0
Gp58_im_re_a4 0 x58_im_a4 x58_re_a4 0 -1474144465.2759433
Rp58_im_im_a4 0 x58_im_a4 5.783268392817006e-09
Cx59_re_a4 x59_re_a4 0 1.0
Gx59_re_a4 0 x59_re_a4 p4 0 0.1414213562373095
Fx59_re_a4 0 x59_re_a4 V4 7.0710678118654755
Rp59_re_re_a4 0 x59_re_a4 5.734252219761168e-09
Gp59_re_im_a4 0 x59_re_a4 x59_im_a4 0 201137530.81086907
Cx59_im_a4 x59_im_a4 0 1.0
Gp59_im_re_a4 0 x59_im_a4 x59_re_a4 0 -201137530.81086907
Rp59_im_im_a4 0 x59_im_a4 5.734252219761168e-09
Cx60_re_a4 x60_re_a4 0 1.0
Gx60_re_a4 0 x60_re_a4 p4 0 0.1414213562373095
Fx60_re_a4 0 x60_re_a4 V4 7.0710678118654755
Rp60_re_re_a4 0 x60_re_a4 5.652786094011291e-09
Gp60_re_im_a4 0 x60_re_a4 x60_im_a4 0 618651646.662869
Cx60_im_a4 x60_im_a4 0 1.0
Gp60_im_re_a4 0 x60_im_a4 x60_re_a4 0 -618651646.662869
Rp60_im_im_a4 0 x60_im_a4 5.652786094011291e-09
.ENDS s_equivalent
