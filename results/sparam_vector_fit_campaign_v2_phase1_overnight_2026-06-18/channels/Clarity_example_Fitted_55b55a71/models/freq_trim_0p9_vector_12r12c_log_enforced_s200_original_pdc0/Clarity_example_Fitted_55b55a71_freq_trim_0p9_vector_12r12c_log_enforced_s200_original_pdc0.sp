* EQUIVALENT CIRCUIT FOR VECTOR FITTED S-MATRIX
* Created using scikit-rf vectorFitting.py
*
.SUBCKT s_equivalent p1 p2
*
* Port network for port 1
V1 p1 s1 0
R1 s1 0 50.0
Gd1_1 0 s1 p1 0 0.010244609492805114
Fd1_1 0 s1 V1 0.5122304746402557
Gr1_1_1 0 s1 x1_a1 0 4959188658422.609
Gr2_1_1 0 s1 x2_a1 0 -5904501028.101476
Gr3_1_1 0 s1 x3_a1 0 2401205822547440.0
Gr4_re_1_1 0 s1 x4_re_a1 0 1.609039686611845e+17
Gr4_im_1_1 0 s1 x4_im_a1 0 -2577346974170002.0
Gr5_re_1_1 0 s1 x5_re_a1 0 -6.666110621924289e+17
Gr5_im_1_1 0 s1 x5_im_a1 0 5.8712795395945e+17
Gr6_re_1_1 0 s1 x6_re_a1 0 -6.066701431814378e+17
Gr6_im_1_1 0 s1 x6_im_a1 0 -1.8004989322894513e+18
Gr7_re_1_1 0 s1 x7_re_a1 0 2.4496676494436275e+18
Gr7_im_1_1 0 s1 x7_im_a1 0 6.898640493544804e+18
Gr8_re_1_1 0 s1 x8_re_a1 0 1.1303149095749558e+18
Gr8_im_1_1 0 s1 x8_im_a1 0 -4.476445524006446e+18
Gr9_re_1_1 0 s1 x9_re_a1 0 -1.4291650704584586e+18
Gr9_im_1_1 0 s1 x9_im_a1 0 5.5897022069952576e+17
Gr10_re_1_1 0 s1 x10_re_a1 0 -9.583555224359324e+17
Gr10_im_1_1 0 s1 x10_im_a1 0 -1.064504723484086e+19
Gr11_re_1_1 0 s1 x11_re_a1 0 1.3208326690070302e+17
Gr11_im_1_1 0 s1 x11_im_a1 0 -1.1785670448629796e+18
Gr12_1_1 0 s1 x12_a1 0 -4.814039289671458e+17
Gr13_1_1 0 s1 x13_a1 0 -6.773292302242609e+16
Gr14_re_1_1 0 s1 x14_re_a1 0 2.232279753087201e+18
Gr14_im_1_1 0 s1 x14_im_a1 0 1.3007457865737984e+17
Gr15_1_1 0 s1 x15_a1 0 -3698238737192563.0
Gr16_1_1 0 s1 x16_a1 0 -1.3296456358638108e+16
Gr17_re_1_1 0 s1 x17_re_a1 0 -1.2632713893569354e+18
Gr17_im_1_1 0 s1 x17_im_a1 0 3.007937618467207e+16
Gr18_re_1_1 0 s1 x18_re_a1 0 -8.163345313555538e+17
Gr18_im_1_1 0 s1 x18_im_a1 0 1.3916912147121354e+16
Gr19_1_1 0 s1 x19_a1 0 -2.7887041771271936e+16
Gr20_re_1_1 0 s1 x20_re_a1 0 -4.134648379627776e+16
Gr20_im_1_1 0 s1 x20_im_a1 0 4431693106999497.0
Gr21_1_1 0 s1 x21_a1 0 -2.3409296578871068e+16
Gr22_re_1_1 0 s1 x22_re_a1 0 -9679363082547170.0
Gr22_im_1_1 0 s1 x22_im_a1 0 6.9438617371130664e+16
Gr23_1_1 0 s1 x23_a1 0 -1.2605301378896554e+16
Gd1_2 0 s1 p2 0 -3.841442207447245e-05
Fd1_2 0 s1 V2 -0.0019207211037236224
Gr1_1_2 0 s1 x1_a2 0 18945291814.898132
Gr2_1_2 0 s1 x2_a2 0 119961629.2015332
Gr3_1_2 0 s1 x3_a2 0 -161794707033880.44
Gr4_re_1_2 0 s1 x4_re_a2 0 -1.2849003043828382e+16
Gr4_im_1_2 0 s1 x4_im_a2 0 -1079530769131528.4
Gr5_re_1_2 0 s1 x5_re_a2 0 5.245445157506676e+16
Gr5_im_1_2 0 s1 x5_im_a2 0 -4.16374461490843e+16
Gr6_re_1_2 0 s1 x6_re_a2 0 3.875673014172437e+16
Gr6_im_1_2 0 s1 x6_im_a2 0 1.4866105975539603e+17
Gr7_re_1_2 0 s1 x7_re_a2 0 -1.7577816832414662e+17
Gr7_im_1_2 0 s1 x7_im_a2 0 -5.5773376544503706e+17
Gr8_re_1_2 0 s1 x8_re_a2 0 -8.977009281343227e+16
Gr8_im_1_2 0 s1 x8_im_a2 0 3.436885803107578e+17
Gr9_re_1_2 0 s1 x9_re_a2 0 1.1876893037514186e+17
Gr9_im_1_2 0 s1 x9_im_a2 0 -4.319957323858881e+16
Gr10_re_1_2 0 s1 x10_re_a2 0 7.28220236958845e+16
Gr10_im_1_2 0 s1 x10_im_a2 0 8.476809181503963e+17
Gr11_re_1_2 0 s1 x11_re_a2 0 -1.920313148364127e+16
Gr11_im_1_2 0 s1 x11_im_a2 0 9.635957541072117e+16
Gr12_1_2 0 s1 x12_a2 0 3.43907807445171e+16
Gr13_1_2 0 s1 x13_a2 0 3240292472092398.0
Gr14_re_1_2 0 s1 x14_re_a2 0 -1.8602652828692304e+17
Gr14_im_1_2 0 s1 x14_im_a2 0 -1.1093851760322804e+16
Gr15_1_2 0 s1 x15_a2 0 -161960673076580.25
Gr16_1_2 0 s1 x16_a2 0 806665939700547.2
Gr17_re_1_2 0 s1 x17_re_a2 0 1.0659832159215773e+17
Gr17_im_1_2 0 s1 x17_im_a2 0 -2505204818258766.0
Gr18_re_1_2 0 s1 x18_re_a2 0 6.833493065639538e+16
Gr18_im_1_2 0 s1 x18_im_a2 0 -1153786093229412.2
Gr19_1_2 0 s1 x19_a2 0 2249112753672037.5
Gr20_re_1_2 0 s1 x20_re_a2 0 3433917046570835.5
Gr20_im_1_2 0 s1 x20_im_a2 0 -365271835908498.06
Gr21_1_2 0 s1 x21_a2 0 1920278396813382.8
Gr22_re_1_2 0 s1 x22_re_a2 0 796484761303198.0
Gr22_im_1_2 0 s1 x22_im_a2 0 -5750967475478098.0
Gr23_1_2 0 s1 x23_a2 0 1038893781418267.6
*
* State networks driven by port 1
Cx1_a1 x1_a1 0 1.0
Gx1_a1 0 x1_a1 p1 0 0.07071067811865475
Fx1_a1 0 x1_a1 V1 3.5355339059327378
Rp1_a1 0 x1_a1 2.8055349088144472e-14
Cx2_a1 x2_a1 0 1.0
Gx2_a1 0 x2_a1 p1 0 0.07071067811865475
Fx2_a1 0 x2_a1 V1 3.5355339059327378
Rp2_a1 0 x2_a1 1.3423154085133985e-12
Cx3_a1 x3_a1 0 1.0
Gx3_a1 0 x3_a1 p1 0 0.07071067811865475
Fx3_a1 0 x3_a1 V1 3.5355339059327378
Rp3_a1 0 x3_a1 2.52178394656533e-11
Cx4_re_a1 x4_re_a1 0 1.0
Gx4_re_a1 0 x4_re_a1 p1 0 0.1414213562373095
Fx4_re_a1 0 x4_re_a1 V1 7.0710678118654755
Rp4_re_re_a1 0 x4_re_a1 1.5797398241227735e-10
Gp4_re_im_a1 0 x4_re_a1 x4_im_a1 0 18767775093.651196
Cx4_im_a1 x4_im_a1 0 1.0
Gp4_im_re_a1 0 x4_im_a1 x4_re_a1 0 -18767775093.651196
Rp4_im_im_a1 0 x4_im_a1 1.5797398241227735e-10
Cx5_re_a1 x5_re_a1 0 1.0
Gx5_re_a1 0 x5_re_a1 p1 0 0.1414213562373095
Fx5_re_a1 0 x5_re_a1 V1 7.0710678118654755
Rp5_re_re_a1 0 x5_re_a1 6.119359543666775e-11
Gp5_re_im_a1 0 x5_re_a1 x5_im_a1 0 10685028936.287853
Cx5_im_a1 x5_im_a1 0 1.0
Gp5_im_re_a1 0 x5_im_a1 x5_re_a1 0 -10685028936.287853
Rp5_im_im_a1 0 x5_im_a1 6.119359543666775e-11
Cx6_re_a1 x6_re_a1 0 1.0
Gx6_re_a1 0 x6_re_a1 p1 0 0.1414213562373095
Fx6_re_a1 0 x6_re_a1 V1 7.0710678118654755
Rp6_re_re_a1 0 x6_re_a1 1.7986110800458453e-10
Gp6_re_im_a1 0 x6_re_a1 x6_im_a1 0 13979976784.150835
Cx6_im_a1 x6_im_a1 0 1.0
Gp6_im_re_a1 0 x6_im_a1 x6_re_a1 0 -13979976784.150835
Rp6_im_im_a1 0 x6_im_a1 1.7986110800458453e-10
Cx7_re_a1 x7_re_a1 0 1.0
Gx7_re_a1 0 x7_re_a1 p1 0 0.1414213562373095
Fx7_re_a1 0 x7_re_a1 V1 7.0710678118654755
Rp7_re_re_a1 0 x7_re_a1 1.287294616280852e-10
Gp7_re_im_a1 0 x7_re_a1 x7_im_a1 0 10094140165.177664
Cx7_im_a1 x7_im_a1 0 1.0
Gp7_im_re_a1 0 x7_im_a1 x7_re_a1 0 -10094140165.177664
Rp7_im_im_a1 0 x7_im_a1 1.287294616280852e-10
Cx8_re_a1 x8_re_a1 0 1.0
Gx8_re_a1 0 x8_re_a1 p1 0 0.1414213562373095
Fx8_re_a1 0 x8_re_a1 V1 7.0710678118654755
Rp8_re_re_a1 0 x8_re_a1 1.0611556024130166e-10
Gp8_re_im_a1 0 x8_re_a1 x8_im_a1 0 7054645181.264583
Cx8_im_a1 x8_im_a1 0 1.0
Gp8_im_re_a1 0 x8_im_a1 x8_re_a1 0 -7054645181.264583
Rp8_im_im_a1 0 x8_im_a1 1.0611556024130166e-10
Cx9_re_a1 x9_re_a1 0 1.0
Gx9_re_a1 0 x9_re_a1 p1 0 0.1414213562373095
Fx9_re_a1 0 x9_re_a1 V1 7.0710678118654755
Rp9_re_re_a1 0 x9_re_a1 1.4065147559640943e-10
Gp9_re_im_a1 0 x9_re_a1 x9_im_a1 0 7555402656.564148
Cx9_im_a1 x9_im_a1 0 1.0
Gp9_im_re_a1 0 x9_im_a1 x9_re_a1 0 -7555402656.564148
Rp9_im_im_a1 0 x9_im_a1 1.4065147559640943e-10
Cx10_re_a1 x10_re_a1 0 1.0
Gx10_re_a1 0 x10_re_a1 p1 0 0.1414213562373095
Fx10_re_a1 0 x10_re_a1 V1 7.0710678118654755
Rp10_re_re_a1 0 x10_re_a1 1.2837618522275094e-10
Gp10_re_im_a1 0 x10_re_a1 x10_im_a1 0 1626944951.327316
Cx10_im_a1 x10_im_a1 0 1.0
Gp10_im_re_a1 0 x10_im_a1 x10_re_a1 0 -1626944951.327316
Rp10_im_im_a1 0 x10_im_a1 1.2837618522275094e-10
Cx11_re_a1 x11_re_a1 0 1.0
Gx11_re_a1 0 x11_re_a1 p1 0 0.1414213562373095
Fx11_re_a1 0 x11_re_a1 V1 7.0710678118654755
Rp11_re_re_a1 0 x11_re_a1 3.329197079666697e-10
Gp11_re_im_a1 0 x11_re_a1 x11_im_a1 0 4245341248.5010123
Cx11_im_a1 x11_im_a1 0 1.0
Gp11_im_re_a1 0 x11_im_a1 x11_re_a1 0 -4245341248.5010123
Rp11_im_im_a1 0 x11_im_a1 3.329197079666697e-10
Cx12_a1 x12_a1 0 1.0
Gx12_a1 0 x12_a1 p1 0 0.07071067811865475
Fx12_a1 0 x12_a1 V1 3.5355339059327378
Rp12_a1 0 x12_a1 1.774931090390094e-10
Cx13_a1 x13_a1 0 1.0
Gx13_a1 0 x13_a1 p1 0 0.07071067811865475
Fx13_a1 0 x13_a1 V1 3.5355339059327378
Rp13_a1 0 x13_a1 2.486800112645268e-10
Cx14_re_a1 x14_re_a1 0 1.0
Gx14_re_a1 0 x14_re_a1 p1 0 0.1414213562373095
Fx14_re_a1 0 x14_re_a1 V1 7.0710678118654755
Rp14_re_re_a1 0 x14_re_a1 2.0854326750963615e-09
Gp14_re_im_a1 0 x14_re_a1 x14_im_a1 0 2075032419.7847686
Cx14_im_a1 x14_im_a1 0 1.0
Gp14_im_re_a1 0 x14_im_a1 x14_re_a1 0 -2075032419.7847686
Rp14_im_im_a1 0 x14_im_a1 2.0854326750963615e-09
Cx15_a1 x15_a1 0 1.0
Gx15_a1 0 x15_a1 p1 0 0.07071067811865475
Fx15_a1 0 x15_a1 V1 3.5355339059327378
Rp15_a1 0 x15_a1 4.5472029178370566e-10
Cx16_a1 x16_a1 0 1.0
Gx16_a1 0 x16_a1 p1 0 0.07071067811865475
Fx16_a1 0 x16_a1 V1 3.5355339059327378
Rp16_a1 0 x16_a1 5.348956226505701e-10
Cx17_re_a1 x17_re_a1 0 1.0
Gx17_re_a1 0 x17_re_a1 p1 0 0.1414213562373095
Fx17_re_a1 0 x17_re_a1 V1 7.0710678118654755
Rp17_re_re_a1 0 x17_re_a1 1.8638641117433502e-08
Gp17_re_im_a1 0 x17_re_a1 x17_im_a1 0 865268350.4800653
Cx17_im_a1 x17_im_a1 0 1.0
Gp17_im_re_a1 0 x17_im_a1 x17_re_a1 0 -865268350.4800653
Rp17_im_im_a1 0 x17_im_a1 1.8638641117433502e-08
Cx18_re_a1 x18_re_a1 0 1.0
Gx18_re_a1 0 x18_re_a1 p1 0 0.1414213562373095
Fx18_re_a1 0 x18_re_a1 V1 7.0710678118654755
Rp18_re_re_a1 0 x18_re_a1 2.360419503108212e-08
Gp18_re_im_a1 0 x18_re_a1 x18_im_a1 0 574470381.2139174
Cx18_im_a1 x18_im_a1 0 1.0
Gp18_im_re_a1 0 x18_im_a1 x18_re_a1 0 -574470381.2139174
Rp18_im_im_a1 0 x18_im_a1 2.360419503108212e-08
Cx19_a1 x19_a1 0 1.0
Gx19_a1 0 x19_a1 p1 0 0.07071067811865475
Fx19_a1 0 x19_a1 V1 3.5355339059327378
Rp19_a1 0 x19_a1 9.244782412554334e-10
Cx20_re_a1 x20_re_a1 0 1.0
Gx20_re_a1 0 x20_re_a1 p1 0 0.1414213562373095
Fx20_re_a1 0 x20_re_a1 V1 7.0710678118654755
Rp20_re_re_a1 0 x20_re_a1 1.8407694116681472e-08
Gp20_re_im_a1 0 x20_re_a1 x20_im_a1 0 252027529.37913004
Cx20_im_a1 x20_im_a1 0 1.0
Gp20_im_re_a1 0 x20_im_a1 x20_re_a1 0 -252027529.37913004
Rp20_im_im_a1 0 x20_im_a1 1.8407694116681472e-08
Cx21_a1 x21_a1 0 1.0
Gx21_a1 0 x21_a1 p1 0 0.07071067811865475
Fx21_a1 0 x21_a1 V1 3.5355339059327378
Rp21_a1 0 x21_a1 1.4405717724656845e-09
Cx22_re_a1 x22_re_a1 0 1.0
Gx22_re_a1 0 x22_re_a1 p1 0 0.1414213562373095
Fx22_re_a1 0 x22_re_a1 V1 7.0710678118654755
Rp22_re_re_a1 0 x22_re_a1 1.885888135527691e-09
Gp22_re_im_a1 0 x22_re_a1 x22_im_a1 0 83367464.75098863
Cx22_im_a1 x22_im_a1 0 1.0
Gp22_im_re_a1 0 x22_im_a1 x22_re_a1 0 -83367464.75098863
Rp22_im_im_a1 0 x22_im_a1 1.885888135527691e-09
Cx23_a1 x23_a1 0 1.0
Gx23_a1 0 x23_a1 p1 0 0.07071067811865475
Fx23_a1 0 x23_a1 V1 3.5355339059327378
Rp23_a1 0 x23_a1 2.862913817065024e-09
*
* Port network for port 2
V2 p2 s2 0
R2 s2 0 50.0
Gd2_1 0 s2 p1 0 -3.841442207447245e-05
Fd2_1 0 s2 V1 -0.0019207211037236224
Gr1_2_1 0 s2 x1_a1 0 18945292404.440926
Gr2_2_1 0 s2 x2_a1 0 119961590.58096331
Gr3_2_1 0 s2 x3_a1 0 -161794477729367.8
Gr4_re_2_1 0 s2 x4_re_a1 0 -1.2848985476405626e+16
Gr4_im_2_1 0 s2 x4_im_a1 0 -1079529718337316.2
Gr5_re_2_1 0 s2 x5_re_a1 0 5.245437968367363e+16
Gr5_im_2_1 0 s2 x5_im_a1 0 -4.163738769648004e+16
Gr6_re_2_1 0 s2 x6_re_a1 0 3.875667395403738e+16
Gr6_im_2_1 0 s2 x6_im_a1 0 1.486608583229106e+17
Gr7_re_2_1 0 s2 x7_re_a1 0 -1.757779218390908e+17
Gr7_im_2_1 0 s2 x7_im_a1 0 -5.577330064129408e+17
Gr8_re_2_1 0 s2 x8_re_a1 0 -8.976997011152037e+16
Gr8_im_2_1 0 s2 x8_im_a1 0 3.436881069105211e+17
Gr9_re_2_1 0 s2 x9_re_a1 0 1.1876876983605702e+17
Gr9_im_2_1 0 s2 x9_im_a1 0 -4.319951369152717e+16
Gr10_re_2_1 0 s2 x10_re_a1 0 7.282192309416542e+16
Gr10_im_2_1 0 s2 x10_im_a1 0 8.476797606875224e+17
Gr11_re_2_1 0 s2 x11_re_a1 0 -1.9203108185134184e+16
Gr11_im_2_1 0 s2 x11_im_a1 0 9.635944465286909e+16
Gr12_2_1 0 s2 x12_a1 0 3.439073247068499e+16
Gr13_2_1 0 s2 x13_a1 0 3240287333077790.0
Gr14_re_2_1 0 s2 x14_re_a1 0 -1.8602627699904816e+17
Gr14_im_2_1 0 s2 x14_im_a1 0 -1.109383686014932e+16
Gr15_2_1 0 s2 x15_a1 0 -161960600111818.16
Gr16_2_1 0 s2 x16_a1 0 806664757750528.4
Gr17_re_2_1 0 s2 x17_re_a1 0 1.0659817806044254e+17
Gr17_im_2_1 0 s2 x17_im_a1 0 -2505201434934625.0
Gr18_re_2_1 0 s2 x18_re_a1 0 6.833483846624745e+16
Gr18_im_2_1 0 s2 x18_im_a1 0 -1153784533512155.8
Gr19_2_1 0 s2 x19_a1 0 2249109694259133.5
Gr20_re_2_1 0 s2 x20_re_a1 0 3433912406036407.5
Gr20_im_2_1 0 s2 x20_im_a1 0 -365271341524179.2
Gr21_2_1 0 s2 x21_a1 0 1920275794862153.5
Gr22_re_2_1 0 s2 x22_re_a1 0 796483682844475.1
Gr22_im_2_1 0 s2 x22_im_a1 0 -5750959699939420.0
Gr23_2_1 0 s2 x23_a1 0 1038892375245678.5
Gd2_2 0 s2 p2 0 0.010246791931467903
Fd2_2 0 s2 V2 0.5123395965733951
Gr1_2_2 0 s2 x1_a2 0 4958135848504.634
Gr2_2_2 0 s2 x2_a2 0 -5916546798.373393
Gr3_2_2 0 s2 x3_a2 0 2402578548667679.5
Gr4_re_2_2 0 s2 x4_re_a2 0 1.6106560431755747e+17
Gr4_im_2_2 0 s2 x4_im_a2 0 -2538653179142618.5
Gr5_re_2_2 0 s2 x5_re_a2 0 -6.672525796611226e+17
Gr5_im_2_2 0 s2 x5_im_a2 0 5.875405169934593e+17
Gr6_re_2_2 0 s2 x6_re_a2 0 -6.069677670940605e+17
Gr6_im_2_2 0 s2 x6_im_a2 0 -1.802456393549544e+18
Gr7_re_2_2 0 s2 x7_re_a2 0 2.451474099478564e+18
Gr7_im_2_2 0 s2 x7_im_a2 0 6.905741388092677e+18
Gr8_re_2_2 0 s2 x8_re_a2 0 1.1314269373350198e+18
Gr8_im_2_2 0 s2 x8_im_a2 0 -4.4804573451559306e+18
Gr9_re_2_2 0 s2 x9_re_a2 0 -1.4307378614231357e+18
Gr9_im_2_2 0 s2 x9_im_a2 0 5.5948575161276454e+17
Gr10_re_2_2 0 s2 x10_re_a2 0 -9.591914390181733e+17
Gr10_im_2_2 0 s2 x10_im_a2 0 -1.0655573753022552e+19
Gr11_re_2_2 0 s2 x11_re_a2 0 1.324909383757412e+17
Gr11_im_2_2 0 s2 x11_im_a2 0 -1.1798135731162225e+18
Gr12_2_2 0 s2 x12_a2 0 -4.8175368071950445e+17
Gr13_2_2 0 s2 x13_a2 0 -6.773082247120922e+16
Gr14_re_2_2 0 s2 x14_re_a2 0 2.2347531847430372e+18
Gr14_im_2_2 0 s2 x14_im_a2 0 1.3022666652908427e+17
Gr15_2_2 0 s2 x15_a2 0 -3687127707264550.0
Gr16_2_2 0 s2 x16_a2 0 -1.3301394419582196e+16
Gr17_re_2_2 0 s2 x17_re_a2 0 -1.264711977540329e+18
Gr17_im_2_2 0 s2 x17_im_a2 0 3.011261210336552e+16
Gr18_re_2_2 0 s2 x18_re_a2 0 -8.172480816309405e+17
Gr18_im_2_2 0 s2 x18_im_a2 0 1.3932112716008898e+16
Gr19_2_2 0 s2 x19_a2 0 -2.7915446027490868e+16
Gr20_re_2_2 0 s2 x20_re_a2 0 -4.13918548369252e+16
Gr20_im_2_2 0 s2 x20_im_a2 0 4436461867530551.5
Gr21_2_2 0 s2 x21_a2 0 -2.343419121467782e+16
Gr22_re_2_2 0 s2 x22_re_a2 0 -9689737331095406.0
Gr22_im_2_2 0 s2 x22_im_a2 0 6.9514248492198e+16
Gr23_2_2 0 s2 x23_a2 0 -1.2618864784136196e+16
*
* State networks driven by port 2
Cx1_a2 x1_a2 0 1.0
Gx1_a2 0 x1_a2 p2 0 0.07071067811865475
Fx1_a2 0 x1_a2 V2 3.5355339059327378
Rp1_a2 0 x1_a2 2.8055349088144472e-14
Cx2_a2 x2_a2 0 1.0
Gx2_a2 0 x2_a2 p2 0 0.07071067811865475
Fx2_a2 0 x2_a2 V2 3.5355339059327378
Rp2_a2 0 x2_a2 1.3423154085133985e-12
Cx3_a2 x3_a2 0 1.0
Gx3_a2 0 x3_a2 p2 0 0.07071067811865475
Fx3_a2 0 x3_a2 V2 3.5355339059327378
Rp3_a2 0 x3_a2 2.52178394656533e-11
Cx4_re_a2 x4_re_a2 0 1.0
Gx4_re_a2 0 x4_re_a2 p2 0 0.1414213562373095
Fx4_re_a2 0 x4_re_a2 V2 7.0710678118654755
Rp4_re_re_a2 0 x4_re_a2 1.5797398241227735e-10
Gp4_re_im_a2 0 x4_re_a2 x4_im_a2 0 18767775093.651196
Cx4_im_a2 x4_im_a2 0 1.0
Gp4_im_re_a2 0 x4_im_a2 x4_re_a2 0 -18767775093.651196
Rp4_im_im_a2 0 x4_im_a2 1.5797398241227735e-10
Cx5_re_a2 x5_re_a2 0 1.0
Gx5_re_a2 0 x5_re_a2 p2 0 0.1414213562373095
Fx5_re_a2 0 x5_re_a2 V2 7.0710678118654755
Rp5_re_re_a2 0 x5_re_a2 6.119359543666775e-11
Gp5_re_im_a2 0 x5_re_a2 x5_im_a2 0 10685028936.287853
Cx5_im_a2 x5_im_a2 0 1.0
Gp5_im_re_a2 0 x5_im_a2 x5_re_a2 0 -10685028936.287853
Rp5_im_im_a2 0 x5_im_a2 6.119359543666775e-11
Cx6_re_a2 x6_re_a2 0 1.0
Gx6_re_a2 0 x6_re_a2 p2 0 0.1414213562373095
Fx6_re_a2 0 x6_re_a2 V2 7.0710678118654755
Rp6_re_re_a2 0 x6_re_a2 1.7986110800458453e-10
Gp6_re_im_a2 0 x6_re_a2 x6_im_a2 0 13979976784.150835
Cx6_im_a2 x6_im_a2 0 1.0
Gp6_im_re_a2 0 x6_im_a2 x6_re_a2 0 -13979976784.150835
Rp6_im_im_a2 0 x6_im_a2 1.7986110800458453e-10
Cx7_re_a2 x7_re_a2 0 1.0
Gx7_re_a2 0 x7_re_a2 p2 0 0.1414213562373095
Fx7_re_a2 0 x7_re_a2 V2 7.0710678118654755
Rp7_re_re_a2 0 x7_re_a2 1.287294616280852e-10
Gp7_re_im_a2 0 x7_re_a2 x7_im_a2 0 10094140165.177664
Cx7_im_a2 x7_im_a2 0 1.0
Gp7_im_re_a2 0 x7_im_a2 x7_re_a2 0 -10094140165.177664
Rp7_im_im_a2 0 x7_im_a2 1.287294616280852e-10
Cx8_re_a2 x8_re_a2 0 1.0
Gx8_re_a2 0 x8_re_a2 p2 0 0.1414213562373095
Fx8_re_a2 0 x8_re_a2 V2 7.0710678118654755
Rp8_re_re_a2 0 x8_re_a2 1.0611556024130166e-10
Gp8_re_im_a2 0 x8_re_a2 x8_im_a2 0 7054645181.264583
Cx8_im_a2 x8_im_a2 0 1.0
Gp8_im_re_a2 0 x8_im_a2 x8_re_a2 0 -7054645181.264583
Rp8_im_im_a2 0 x8_im_a2 1.0611556024130166e-10
Cx9_re_a2 x9_re_a2 0 1.0
Gx9_re_a2 0 x9_re_a2 p2 0 0.1414213562373095
Fx9_re_a2 0 x9_re_a2 V2 7.0710678118654755
Rp9_re_re_a2 0 x9_re_a2 1.4065147559640943e-10
Gp9_re_im_a2 0 x9_re_a2 x9_im_a2 0 7555402656.564148
Cx9_im_a2 x9_im_a2 0 1.0
Gp9_im_re_a2 0 x9_im_a2 x9_re_a2 0 -7555402656.564148
Rp9_im_im_a2 0 x9_im_a2 1.4065147559640943e-10
Cx10_re_a2 x10_re_a2 0 1.0
Gx10_re_a2 0 x10_re_a2 p2 0 0.1414213562373095
Fx10_re_a2 0 x10_re_a2 V2 7.0710678118654755
Rp10_re_re_a2 0 x10_re_a2 1.2837618522275094e-10
Gp10_re_im_a2 0 x10_re_a2 x10_im_a2 0 1626944951.327316
Cx10_im_a2 x10_im_a2 0 1.0
Gp10_im_re_a2 0 x10_im_a2 x10_re_a2 0 -1626944951.327316
Rp10_im_im_a2 0 x10_im_a2 1.2837618522275094e-10
Cx11_re_a2 x11_re_a2 0 1.0
Gx11_re_a2 0 x11_re_a2 p2 0 0.1414213562373095
Fx11_re_a2 0 x11_re_a2 V2 7.0710678118654755
Rp11_re_re_a2 0 x11_re_a2 3.329197079666697e-10
Gp11_re_im_a2 0 x11_re_a2 x11_im_a2 0 4245341248.5010123
Cx11_im_a2 x11_im_a2 0 1.0
Gp11_im_re_a2 0 x11_im_a2 x11_re_a2 0 -4245341248.5010123
Rp11_im_im_a2 0 x11_im_a2 3.329197079666697e-10
Cx12_a2 x12_a2 0 1.0
Gx12_a2 0 x12_a2 p2 0 0.07071067811865475
Fx12_a2 0 x12_a2 V2 3.5355339059327378
Rp12_a2 0 x12_a2 1.774931090390094e-10
Cx13_a2 x13_a2 0 1.0
Gx13_a2 0 x13_a2 p2 0 0.07071067811865475
Fx13_a2 0 x13_a2 V2 3.5355339059327378
Rp13_a2 0 x13_a2 2.486800112645268e-10
Cx14_re_a2 x14_re_a2 0 1.0
Gx14_re_a2 0 x14_re_a2 p2 0 0.1414213562373095
Fx14_re_a2 0 x14_re_a2 V2 7.0710678118654755
Rp14_re_re_a2 0 x14_re_a2 2.0854326750963615e-09
Gp14_re_im_a2 0 x14_re_a2 x14_im_a2 0 2075032419.7847686
Cx14_im_a2 x14_im_a2 0 1.0
Gp14_im_re_a2 0 x14_im_a2 x14_re_a2 0 -2075032419.7847686
Rp14_im_im_a2 0 x14_im_a2 2.0854326750963615e-09
Cx15_a2 x15_a2 0 1.0
Gx15_a2 0 x15_a2 p2 0 0.07071067811865475
Fx15_a2 0 x15_a2 V2 3.5355339059327378
Rp15_a2 0 x15_a2 4.5472029178370566e-10
Cx16_a2 x16_a2 0 1.0
Gx16_a2 0 x16_a2 p2 0 0.07071067811865475
Fx16_a2 0 x16_a2 V2 3.5355339059327378
Rp16_a2 0 x16_a2 5.348956226505701e-10
Cx17_re_a2 x17_re_a2 0 1.0
Gx17_re_a2 0 x17_re_a2 p2 0 0.1414213562373095
Fx17_re_a2 0 x17_re_a2 V2 7.0710678118654755
Rp17_re_re_a2 0 x17_re_a2 1.8638641117433502e-08
Gp17_re_im_a2 0 x17_re_a2 x17_im_a2 0 865268350.4800653
Cx17_im_a2 x17_im_a2 0 1.0
Gp17_im_re_a2 0 x17_im_a2 x17_re_a2 0 -865268350.4800653
Rp17_im_im_a2 0 x17_im_a2 1.8638641117433502e-08
Cx18_re_a2 x18_re_a2 0 1.0
Gx18_re_a2 0 x18_re_a2 p2 0 0.1414213562373095
Fx18_re_a2 0 x18_re_a2 V2 7.0710678118654755
Rp18_re_re_a2 0 x18_re_a2 2.360419503108212e-08
Gp18_re_im_a2 0 x18_re_a2 x18_im_a2 0 574470381.2139174
Cx18_im_a2 x18_im_a2 0 1.0
Gp18_im_re_a2 0 x18_im_a2 x18_re_a2 0 -574470381.2139174
Rp18_im_im_a2 0 x18_im_a2 2.360419503108212e-08
Cx19_a2 x19_a2 0 1.0
Gx19_a2 0 x19_a2 p2 0 0.07071067811865475
Fx19_a2 0 x19_a2 V2 3.5355339059327378
Rp19_a2 0 x19_a2 9.244782412554334e-10
Cx20_re_a2 x20_re_a2 0 1.0
Gx20_re_a2 0 x20_re_a2 p2 0 0.1414213562373095
Fx20_re_a2 0 x20_re_a2 V2 7.0710678118654755
Rp20_re_re_a2 0 x20_re_a2 1.8407694116681472e-08
Gp20_re_im_a2 0 x20_re_a2 x20_im_a2 0 252027529.37913004
Cx20_im_a2 x20_im_a2 0 1.0
Gp20_im_re_a2 0 x20_im_a2 x20_re_a2 0 -252027529.37913004
Rp20_im_im_a2 0 x20_im_a2 1.8407694116681472e-08
Cx21_a2 x21_a2 0 1.0
Gx21_a2 0 x21_a2 p2 0 0.07071067811865475
Fx21_a2 0 x21_a2 V2 3.5355339059327378
Rp21_a2 0 x21_a2 1.4405717724656845e-09
Cx22_re_a2 x22_re_a2 0 1.0
Gx22_re_a2 0 x22_re_a2 p2 0 0.1414213562373095
Fx22_re_a2 0 x22_re_a2 V2 7.0710678118654755
Rp22_re_re_a2 0 x22_re_a2 1.885888135527691e-09
Gp22_re_im_a2 0 x22_re_a2 x22_im_a2 0 83367464.75098863
Cx22_im_a2 x22_im_a2 0 1.0
Gp22_im_re_a2 0 x22_im_a2 x22_re_a2 0 -83367464.75098863
Rp22_im_im_a2 0 x22_im_a2 1.885888135527691e-09
Cx23_a2 x23_a2 0 1.0
Gx23_a2 0 x23_a2 p2 0 0.07071067811865475
Fx23_a2 0 x23_a2 V2 3.5355339059327378
Rp23_a2 0 x23_a2 2.862913817065024e-09
.ENDS s_equivalent
