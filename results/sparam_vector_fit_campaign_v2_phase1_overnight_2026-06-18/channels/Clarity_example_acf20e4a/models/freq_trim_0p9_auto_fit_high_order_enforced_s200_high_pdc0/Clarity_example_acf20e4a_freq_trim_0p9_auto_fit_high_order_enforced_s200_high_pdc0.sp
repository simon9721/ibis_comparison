* EQUIVALENT CIRCUIT FOR VECTOR FITTED S-MATRIX
* Created using scikit-rf vectorFitting.py
*
.SUBCKT s_equivalent p1 p2
*
* Port network for port 1
V1 p1 s1 0
R1 s1 0 50.0
Gd1_1 0 s1 p1 0 0.057958074430358095
Fd1_1 0 s1 V1 2.897903721517905
Gr1_re_1_1 0 s1 x1_re_a1 0 1922451951632326.5
Gr1_im_1_1 0 s1 x1_im_a1 0 -1497547799836621.0
Gr2_re_1_1 0 s1 x2_re_a1 0 1.4807930478899005e+17
Gr2_im_1_1 0 s1 x2_im_a1 0 -3.5488378179032256e+16
Gr3_re_1_1 0 s1 x3_re_a1 0 -1.7574166463023967e+18
Gr3_im_1_1 0 s1 x3_im_a1 0 -4.826737784685779e+16
Gr4_1_1 0 s1 x4_a1 0 -2.2922864596966486e+19
Gr5_re_1_1 0 s1 x5_re_a1 0 -1.0380051095961393e+18
Gr5_im_1_1 0 s1 x5_im_a1 0 8.92507373921671e+16
Gr6_re_1_1 0 s1 x6_re_a1 0 -4.557476881715662e+18
Gr6_im_1_1 0 s1 x6_im_a1 0 2.4059357281082737e+20
Gr7_1_1 0 s1 x7_a1 0 -3.532085210611197e+18
Gr8_1_1 0 s1 x8_a1 0 2.2885787270566707e+19
Gr9_1_1 0 s1 x9_a1 0 -3.707993629776182e+18
Gr10_1_1 0 s1 x10_a1 0 4.7665927684175544e+16
Gr11_re_1_1 0 s1 x11_re_a1 0 -1.8188318912525967e+18
Gr11_im_1_1 0 s1 x11_im_a1 0 -2.979732698679936e+19
Gr12_1_1 0 s1 x12_a1 0 2.5272947714452533e+19
Gd1_2 0 s1 p2 0 0.043055803694646
Fd1_2 0 s1 V2 2.1527901847323
Gr1_re_1_2 0 s1 x1_re_a2 0 1920239691130999.0
Gr1_im_1_2 0 s1 x1_im_a2 0 -1495833866409191.5
Gr2_re_1_2 0 s1 x2_re_a2 0 1.4790910761668957e+17
Gr2_im_1_2 0 s1 x2_im_a2 0 -3.544754649761722e+16
Gr3_re_1_2 0 s1 x3_re_a2 0 -1.7553969399694464e+18
Gr3_im_1_2 0 s1 x3_im_a2 0 -4.821206726004693e+16
Gr4_1_2 0 s1 x4_a2 0 -2.2896523340471734e+19
Gr5_re_1_2 0 s1 x5_re_a2 0 -1.0368121907151209e+18
Gr5_im_1_2 0 s1 x5_im_a2 0 8.914795910738504e+16
Gr6_re_1_2 0 s1 x6_re_a2 0 -4.552247238333149e+18
Gr6_im_1_2 0 s1 x6_im_a2 0 2.4031715078690737e+20
Gr7_1_2 0 s1 x7_a2 0 -3.528034442548192e+18
Gr8_1_2 0 s1 x8_a2 0 2.2859505132927095e+19
Gr9_1_2 0 s1 x9_a2 0 -3.7037414322595364e+18
Gr10_1_2 0 s1 x10_a2 0 4.7611397357883496e+16
Gr11_re_1_2 0 s1 x11_re_a2 0 -1.816744248979652e+18
Gr11_im_1_2 0 s1 x11_im_a2 0 -2.976316094363897e+19
Gr12_1_2 0 s1 x12_a2 0 2.5243925175321055e+19
*
* State networks driven by port 1
Cx1_re_a1 x1_re_a1 0 1.0
Gx1_re_a1 0 x1_re_a1 p1 0 0.1414213562373095
Fx1_re_a1 0 x1_re_a1 V1 7.0710678118654755
Rp1_re_re_a1 0 x1_re_a1 1.4927961302701732e-10
Gp1_re_im_a1 0 x1_re_a1 x1_im_a1 0 19912036937.681755
Cx1_im_a1 x1_im_a1 0 1.0
Gp1_im_re_a1 0 x1_im_a1 x1_re_a1 0 -19912036937.681755
Rp1_im_im_a1 0 x1_im_a1 1.4927961302701732e-10
Cx2_re_a1 x2_re_a1 0 1.0
Gx2_re_a1 0 x2_re_a1 p1 0 0.1414213562373095
Fx2_re_a1 0 x2_re_a1 V1 7.0710678118654755
Rp2_re_re_a1 0 x2_re_a1 8.477055890865262e-11
Gp2_re_im_a1 0 x2_re_a1 x2_im_a1 0 13102197426.69211
Cx2_im_a1 x2_im_a1 0 1.0
Gp2_im_re_a1 0 x2_im_a1 x2_re_a1 0 -13102197426.69211
Rp2_im_im_a1 0 x2_im_a1 8.477055890865262e-11
Cx3_re_a1 x3_re_a1 0 1.0
Gx3_re_a1 0 x3_re_a1 p1 0 0.1414213562373095
Fx3_re_a1 0 x3_re_a1 V1 7.0710678118654755
Rp3_re_re_a1 0 x3_re_a1 1.0641750597342167e-10
Gp3_re_im_a1 0 x3_re_a1 x3_im_a1 0 8708935257.85962
Cx3_im_a1 x3_im_a1 0 1.0
Gp3_im_re_a1 0 x3_im_a1 x3_re_a1 0 -8708935257.85962
Rp3_im_im_a1 0 x3_im_a1 1.0641750597342167e-10
Cx4_a1 x4_a1 0 1.0
Gx4_a1 0 x4_a1 p1 0 0.07071067811865475
Fx4_a1 0 x4_a1 V1 3.5355339059327378
Rp4_a1 0 x4_a1 1.1471243743765668e-10
Cx5_re_a1 x5_re_a1 0 1.0
Gx5_re_a1 0 x5_re_a1 p1 0 0.1414213562373095
Fx5_re_a1 0 x5_re_a1 V1 7.0710678118654755
Rp5_re_re_a1 0 x5_re_a1 2.71950424442312e-10
Gp5_re_im_a1 0 x5_re_a1 x5_im_a1 0 7991383110.133603
Cx5_im_a1 x5_im_a1 0 1.0
Gp5_im_re_a1 0 x5_im_a1 x5_re_a1 0 -7991383110.133603
Rp5_im_im_a1 0 x5_im_a1 2.71950424442312e-10
Cx6_re_a1 x6_re_a1 0 1.0
Gx6_re_a1 0 x6_re_a1 p1 0 0.1414213562373095
Fx6_re_a1 0 x6_re_a1 V1 7.0710678118654755
Rp6_re_re_a1 0 x6_re_a1 2.27344022116095e-10
Gp6_re_im_a1 0 x6_re_a1 x6_im_a1 0 415837989.8457831
Cx6_im_a1 x6_im_a1 0 1.0
Gp6_im_re_a1 0 x6_im_a1 x6_re_a1 0 -415837989.8457831
Rp6_im_im_a1 0 x6_im_a1 2.27344022116095e-10
Cx7_a1 x7_a1 0 1.0
Gx7_a1 0 x7_a1 p1 0 0.07071067811865475
Fx7_a1 0 x7_a1 V1 3.5355339059327378
Rp7_a1 0 x7_a1 2.3753063613438183e-10
Cx8_a1 x8_a1 0 1.0
Gx8_a1 0 x8_a1 p1 0 0.07071067811865475
Fx8_a1 0 x8_a1 V1 3.5355339059327378
Rp8_a1 0 x8_a1 5.003794255170389e-10
Cx9_a1 x9_a1 0 1.0
Gx9_a1 0 x9_a1 p1 0 0.07071067811865475
Fx9_a1 0 x9_a1 V1 3.5355339059327378
Rp9_a1 0 x9_a1 9.466977519432193e-10
Cx10_a1 x10_a1 0 1.0
Gx10_a1 0 x10_a1 p1 0 0.07071067811865475
Fx10_a1 0 x10_a1 V1 3.5355339059327378
Rp10_a1 0 x10_a1 2.782830520439691e-09
Cx11_re_a1 x11_re_a1 0 1.0
Gx11_re_a1 0 x11_re_a1 p1 0 0.1414213562373095
Fx11_re_a1 0 x11_re_a1 V1 7.0710678118654755
Rp11_re_re_a1 0 x11_re_a1 1.7684265185803724e-09
Gp11_re_im_a1 0 x11_re_a1 x11_im_a1 0 13046720.16210403
Cx11_im_a1 x11_im_a1 0 1.0
Gp11_im_re_a1 0 x11_im_a1 x11_re_a1 0 -13046720.16210403
Rp11_im_im_a1 0 x11_im_a1 1.7684265185803724e-09
Cx12_a1 x12_a1 0 1.0
Gx12_a1 0 x12_a1 p1 0 0.07071067811865475
Fx12_a1 0 x12_a1 V1 3.5355339059327378
Rp12_a1 0 x12_a1 4.746946701794364e-10
*
* Port network for port 2
V2 p2 s2 0
R2 s2 0 50.0
Gd2_1 0 s2 p1 0 0.043055803694646
Fd2_1 0 s2 V1 2.1527901847323
Gr1_re_2_1 0 s2 x1_re_a1 0 1920239789773569.5
Gr1_im_2_1 0 s2 x1_im_a1 0 -1495833828476359.5
Gr2_re_2_1 0 s2 x2_re_a1 0 1.4790911483400573e+17
Gr2_im_2_1 0 s2 x2_im_a1 0 -3.5447542841500252e+16
Gr3_re_2_1 0 s2 x3_re_a1 0 -1.7553970364907825e+18
Gr3_im_2_1 0 s2 x3_im_a1 0 -4.821214547155523e+16
Gr4_2_1 0 s2 x4_a1 0 -2.2896525682771026e+19
Gr5_re_2_1 0 s2 x5_re_a1 0 -1.0368122484960788e+18
Gr5_im_2_1 0 s2 x5_im_a1 0 8.914787699237088e+16
Gr6_re_2_1 0 s2 x6_re_a1 0 -4.5522508633250606e+18
Gr6_im_2_1 0 s2 x6_im_a1 0 2.403171965748332e+20
Gr7_2_1 0 s2 x7_a1 0 -3.5280381771047813e+18
Gr8_2_1 0 s2 x8_a1 0 2.28595144315149e+19
Gr9_2_1 0 s2 x9_a1 0 -3.70374550222206e+18
Gr10_2_1 0 s2 x10_a1 0 4.7611505135673704e+16
Gr11_re_2_1 0 s2 x11_re_a1 0 -1.816745456988608e+18
Gr11_im_2_1 0 s2 x11_im_a1 0 -2.976319554835143e+19
Gr12_2_1 0 s2 x12_a1 0 2.524393587574827e+19
Gd2_2 0 s2 p2 0 0.057859053237655333
Fd2_2 0 s2 V2 2.8929526618827666
Gr1_re_2_2 0 s2 x1_re_a2 0 1918035591902677.0
Gr1_im_2_2 0 s2 x1_im_a2 0 -1494107058005441.0
Gr2_re_2_2 0 s2 x2_re_a2 0 1.4773914439301805e+17
Gr2_im_2_2 0 s2 x2_im_a2 0 -3.5406830956771524e+16
Gr3_re_2_2 0 s2 x3_re_a2 0 -1.7533796835117353e+18
Gr3_im_2_2 0 s2 x3_im_a2 0 -4.815691454986153e+16
Gr4_2_2 0 s2 x4_a2 0 -2.2870215007254286e+19
Gr5_re_2_2 0 s2 x5_re_a2 0 -1.0356207067860575e+18
Gr5_im_2_2 0 s2 x5_im_a2 0 8.904520950286549e+16
Gr6_re_2_2 0 s2 x6_re_a2 0 -4.547027600372899e+18
Gr6_im_2_2 0 s2 x6_im_a2 0 2.4004109662624986e+20
Gr7_2_2 0 s2 x7_a2 0 -3.5239923132804844e+18
Gr8_2_2 0 s2 x8_a2 0 2.283326335741217e+19
Gr9_2_2 0 s2 x9_a2 0 -3.699498561363243e+18
Gr10_2_2 0 s2 x10_a2 0 4.755704721159814e+16
Gr11_re_2_2 0 s2 x11_re_a2 0 -1.814660324451281e+18
Gr11_im_2_2 0 s2 x11_im_a2 0 -2.9729071914145456e+19
Gr12_2_2 0 s2 x12_a2 0 2.5214947678762975e+19
*
* State networks driven by port 2
Cx1_re_a2 x1_re_a2 0 1.0
Gx1_re_a2 0 x1_re_a2 p2 0 0.1414213562373095
Fx1_re_a2 0 x1_re_a2 V2 7.0710678118654755
Rp1_re_re_a2 0 x1_re_a2 1.4927961302701732e-10
Gp1_re_im_a2 0 x1_re_a2 x1_im_a2 0 19912036937.681755
Cx1_im_a2 x1_im_a2 0 1.0
Gp1_im_re_a2 0 x1_im_a2 x1_re_a2 0 -19912036937.681755
Rp1_im_im_a2 0 x1_im_a2 1.4927961302701732e-10
Cx2_re_a2 x2_re_a2 0 1.0
Gx2_re_a2 0 x2_re_a2 p2 0 0.1414213562373095
Fx2_re_a2 0 x2_re_a2 V2 7.0710678118654755
Rp2_re_re_a2 0 x2_re_a2 8.477055890865262e-11
Gp2_re_im_a2 0 x2_re_a2 x2_im_a2 0 13102197426.69211
Cx2_im_a2 x2_im_a2 0 1.0
Gp2_im_re_a2 0 x2_im_a2 x2_re_a2 0 -13102197426.69211
Rp2_im_im_a2 0 x2_im_a2 8.477055890865262e-11
Cx3_re_a2 x3_re_a2 0 1.0
Gx3_re_a2 0 x3_re_a2 p2 0 0.1414213562373095
Fx3_re_a2 0 x3_re_a2 V2 7.0710678118654755
Rp3_re_re_a2 0 x3_re_a2 1.0641750597342167e-10
Gp3_re_im_a2 0 x3_re_a2 x3_im_a2 0 8708935257.85962
Cx3_im_a2 x3_im_a2 0 1.0
Gp3_im_re_a2 0 x3_im_a2 x3_re_a2 0 -8708935257.85962
Rp3_im_im_a2 0 x3_im_a2 1.0641750597342167e-10
Cx4_a2 x4_a2 0 1.0
Gx4_a2 0 x4_a2 p2 0 0.07071067811865475
Fx4_a2 0 x4_a2 V2 3.5355339059327378
Rp4_a2 0 x4_a2 1.1471243743765668e-10
Cx5_re_a2 x5_re_a2 0 1.0
Gx5_re_a2 0 x5_re_a2 p2 0 0.1414213562373095
Fx5_re_a2 0 x5_re_a2 V2 7.0710678118654755
Rp5_re_re_a2 0 x5_re_a2 2.71950424442312e-10
Gp5_re_im_a2 0 x5_re_a2 x5_im_a2 0 7991383110.133603
Cx5_im_a2 x5_im_a2 0 1.0
Gp5_im_re_a2 0 x5_im_a2 x5_re_a2 0 -7991383110.133603
Rp5_im_im_a2 0 x5_im_a2 2.71950424442312e-10
Cx6_re_a2 x6_re_a2 0 1.0
Gx6_re_a2 0 x6_re_a2 p2 0 0.1414213562373095
Fx6_re_a2 0 x6_re_a2 V2 7.0710678118654755
Rp6_re_re_a2 0 x6_re_a2 2.27344022116095e-10
Gp6_re_im_a2 0 x6_re_a2 x6_im_a2 0 415837989.8457831
Cx6_im_a2 x6_im_a2 0 1.0
Gp6_im_re_a2 0 x6_im_a2 x6_re_a2 0 -415837989.8457831
Rp6_im_im_a2 0 x6_im_a2 2.27344022116095e-10
Cx7_a2 x7_a2 0 1.0
Gx7_a2 0 x7_a2 p2 0 0.07071067811865475
Fx7_a2 0 x7_a2 V2 3.5355339059327378
Rp7_a2 0 x7_a2 2.3753063613438183e-10
Cx8_a2 x8_a2 0 1.0
Gx8_a2 0 x8_a2 p2 0 0.07071067811865475
Fx8_a2 0 x8_a2 V2 3.5355339059327378
Rp8_a2 0 x8_a2 5.003794255170389e-10
Cx9_a2 x9_a2 0 1.0
Gx9_a2 0 x9_a2 p2 0 0.07071067811865475
Fx9_a2 0 x9_a2 V2 3.5355339059327378
Rp9_a2 0 x9_a2 9.466977519432193e-10
Cx10_a2 x10_a2 0 1.0
Gx10_a2 0 x10_a2 p2 0 0.07071067811865475
Fx10_a2 0 x10_a2 V2 3.5355339059327378
Rp10_a2 0 x10_a2 2.782830520439691e-09
Cx11_re_a2 x11_re_a2 0 1.0
Gx11_re_a2 0 x11_re_a2 p2 0 0.1414213562373095
Fx11_re_a2 0 x11_re_a2 V2 7.0710678118654755
Rp11_re_re_a2 0 x11_re_a2 1.7684265185803724e-09
Gp11_re_im_a2 0 x11_re_a2 x11_im_a2 0 13046720.16210403
Cx11_im_a2 x11_im_a2 0 1.0
Gp11_im_re_a2 0 x11_im_a2 x11_re_a2 0 -13046720.16210403
Rp11_im_im_a2 0 x11_im_a2 1.7684265185803724e-09
Cx12_a2 x12_a2 0 1.0
Gx12_a2 0 x12_a2 p2 0 0.07071067811865475
Fx12_a2 0 x12_a2 V2 3.5355339059327378
Rp12_a2 0 x12_a2 4.746946701794364e-10
.ENDS s_equivalent
