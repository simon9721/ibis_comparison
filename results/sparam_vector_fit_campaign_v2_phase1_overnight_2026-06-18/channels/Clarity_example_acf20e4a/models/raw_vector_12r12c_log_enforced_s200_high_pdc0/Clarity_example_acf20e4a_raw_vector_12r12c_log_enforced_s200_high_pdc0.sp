* EQUIVALENT CIRCUIT FOR VECTOR FITTED S-MATRIX
* Created using scikit-rf vectorFitting.py
*
.SUBCKT s_equivalent p1 p2
*
* Port network for port 1
V1 p1 s1 0
R1 s1 0 50.0
Gd1_1 0 s1 p1 0 11.60871985314682
Fd1_1 0 s1 V1 580.435992657341
Gr1_1_1 0 s1 x1_a1 0 1.8821450570578002e+21
Gr2_1_1 0 s1 x2_a1 0 -1.7461099737364787e+21
Gr3_re_1_1 0 s1 x3_re_a1 0 -7.08743205310432e+19
Gr3_im_1_1 0 s1 x3_im_a1 0 -5.336735473323506e+19
Gr4_re_1_1 0 s1 x4_re_a1 0 2.644754930450439e+21
Gr4_im_1_1 0 s1 x4_im_a1 0 -1.3666325614673595e+21
Gr5_re_1_1 0 s1 x5_re_a1 0 -4.62817480032286e+20
Gr5_im_1_1 0 s1 x5_im_a1 0 -5.060335866604094e+20
Gr6_re_1_1 0 s1 x6_re_a1 0 1.4791460188720472e+22
Gr6_im_1_1 0 s1 x6_im_a1 0 1.670077850334027e+22
Gr7_re_1_1 0 s1 x7_re_a1 0 -1.1430157574230178e+22
Gr7_im_1_1 0 s1 x7_im_a1 0 -1.5517191528494976e+22
Gr8_1_1 0 s1 x8_a1 0 -1.7611572365949e+21
Gr9_1_1 0 s1 x9_a1 0 1.6787747016530686e+21
Gr10_1_1 0 s1 x10_a1 0 -1.1949834235517585e+22
Gr11_1_1 0 s1 x11_a1 0 9.555305670104661e+20
Gr12_1_1 0 s1 x12_a1 0 1.6489743500163586e+20
Gr13_1_1 0 s1 x13_a1 0 -2.385077962098728e+21
Gr14_1_1 0 s1 x14_a1 0 -1.402685979025402e+21
Gr15_1_1 0 s1 x15_a1 0 -2.3297458108239934e+20
Gr16_1_1 0 s1 x16_a1 0 4.692243774206998e+20
Gr17_1_1 0 s1 x17_a1 0 1.638140905766623e+21
Gr18_1_1 0 s1 x18_a1 0 -1.6115632312944247e+20
Gr19_1_1 0 s1 x19_a1 0 1.5734087541534404e+21
Gr20_1_1 0 s1 x20_a1 0 -2.4419915693681955e+19
Gr21_1_1 0 s1 x21_a1 0 7.055460855756536e+20
Gr22_re_1_1 0 s1 x22_re_a1 0 -1.101833647920124e+19
Gr22_im_1_1 0 s1 x22_im_a1 0 -1.3095456191558328e+21
Gr23_1_1 0 s1 x23_a1 0 2.4341144131348247e+20
Gr24_1_1 0 s1 x24_a1 0 1.7262374849350196e+20
Gr25_1_1 0 s1 x25_a1 0 3.6653066985580487e+19
Gr26_1_1 0 s1 x26_a1 0 -1.3930624563933372e+20
Gr27_1_1 0 s1 x27_a1 0 -1.6318702136568575e+20
Gr28_1_1 0 s1 x28_a1 0 -1.5647203945988165e+20
Gr29_1_1 0 s1 x29_a1 0 -1.5942779014281383e+20
Gr30_1_1 0 s1 x30_a1 0 -1.6124167859671948e+20
Gd1_2 0 s1 p2 0 9.139340114730375
Fd1_2 0 s1 V2 456.9670057365188
Gr1_1_2 0 s1 x1_a2 0 1.4817248839792177e+21
Gr2_1_2 0 s1 x2_a2 0 -1.37463109648284e+21
Gr3_re_1_2 0 s1 x3_re_a2 0 -5.579519720146029e+19
Gr3_im_1_2 0 s1 x3_im_a2 0 -4.201235985420315e+19
Gr4_re_1_2 0 s1 x4_re_a2 0 2.0820507135190518e+21
Gr4_im_1_2 0 s1 x4_im_a2 0 -1.0758795738298778e+21
Gr5_re_1_2 0 s1 x5_re_a2 0 -3.6434949440455246e+20
Gr5_im_1_2 0 s1 x5_im_a2 0 -3.9836762587409246e+20
Gr6_re_1_2 0 s1 x6_re_a2 0 1.1644501613998103e+22
Gr6_im_1_2 0 s1 x6_im_a2 0 1.3147507910608194e+22
Gr7_re_1_2 0 s1 x7_re_a2 0 -8.998330495966134e+21
Gr7_im_1_2 0 s1 x7_im_a2 0 -1.2215742058450634e+22
Gr8_1_2 0 s1 x8_a2 0 -1.3864559616237932e+21
Gr9_1_2 0 s1 x9_a2 0 1.321601688094803e+21
Gr10_1_2 0 s1 x10_a2 0 -9.407413879669901e+21
Gr11_1_2 0 s1 x11_a2 0 7.522320111832417e+20
Gr12_1_2 0 s1 x12_a2 0 1.2981283818246927e+20
Gr13_1_2 0 s1 x13_a2 0 -1.877627990191175e+21
Gr14_1_2 0 s1 x14_a2 0 -1.1042540134569306e+21
Gr15_1_2 0 s1 x15_a2 0 -1.8340730037537125e+20
Gr16_1_2 0 s1 x16_a2 0 3.6939708067787886e+20
Gr17_1_2 0 s1 x17_a2 0 1.2896101176189256e+21
Gr18_1_2 0 s1 x18_a2 0 -1.2686855322994659e+20
Gr19_1_2 0 s1 x19_a2 0 1.2386481111407515e+21
Gr20_1_2 0 s1 x20_a2 0 -1.9224345683858694e+19
Gr21_1_2 0 s1 x21_a2 0 5.554325622422695e+20
Gr22_re_1_2 0 s1 x22_re_a2 0 -8.674084298540858e+18
Gr22_im_1_2 0 s1 x22_im_a2 0 -1.0309190730490923e+21
Gr23_1_2 0 s1 x23_a2 0 1.9162426512074552e+20
Gr24_1_2 0 s1 x24_a2 0 1.3589559000627988e+20
Gr25_1_2 0 s1 x25_a2 0 2.885515227737842e+19
Gr26_1_2 0 s1 x26_a2 0 -1.0966721040581229e+20
Gr27_1_2 0 s1 x27_a2 0 -1.2846674712582952e+20
Gr28_1_2 0 s1 x28_a2 0 -1.2318040576919332e+20
Gr29_1_2 0 s1 x29_a2 0 -1.2550711907581808e+20
Gr30_1_2 0 s1 x30_a2 0 -1.2693580908137116e+20
*
* State networks driven by port 1
Cx1_a1 x1_a1 0 1.0
Gx1_a1 0 x1_a1 p1 0 0.07071067811865475
Fx1_a1 0 x1_a1 V1 3.5355339059327378
Rp1_a1 0 x1_a1 3.105652024533764e-11
Cx2_a1 x2_a1 0 1.0
Gx2_a1 0 x2_a1 p1 0 0.07071067811865475
Fx2_a1 0 x2_a1 V1 3.5355339059327378
Rp2_a1 0 x2_a1 3.0782646267038896e-11
Cx3_re_a1 x3_re_a1 0 1.0
Gx3_re_a1 0 x3_re_a1 p1 0 0.1414213562373095
Fx3_re_a1 0 x3_re_a1 V1 7.0710678118654755
Rp3_re_re_a1 0 x3_re_a1 1.2814917329891254e-10
Gp3_re_im_a1 0 x3_re_a1 x3_im_a1 0 19207576919.03672
Cx3_im_a1 x3_im_a1 0 1.0
Gp3_im_re_a1 0 x3_im_a1 x3_re_a1 0 -19207576919.03672
Rp3_im_im_a1 0 x3_im_a1 1.2814917329891254e-10
Cx4_re_a1 x4_re_a1 0 1.0
Gx4_re_a1 0 x4_re_a1 p1 0 0.1414213562373095
Fx4_re_a1 0 x4_re_a1 V1 7.0710678118654755
Rp4_re_re_a1 0 x4_re_a1 1.0979763413557527e-10
Gp4_re_im_a1 0 x4_re_a1 x4_im_a1 0 14362319466.848879
Cx4_im_a1 x4_im_a1 0 1.0
Gp4_im_re_a1 0 x4_im_a1 x4_re_a1 0 -14362319466.848879
Rp4_im_im_a1 0 x4_im_a1 1.0979763413557527e-10
Cx5_re_a1 x5_re_a1 0 1.0
Gx5_re_a1 0 x5_re_a1 p1 0 0.1414213562373095
Fx5_re_a1 0 x5_re_a1 V1 7.0710678118654755
Rp5_re_re_a1 0 x5_re_a1 1.693552678625933e-10
Gp5_re_im_a1 0 x5_re_a1 x5_im_a1 0 15247502996.091112
Cx5_im_a1 x5_im_a1 0 1.0
Gp5_im_re_a1 0 x5_im_a1 x5_re_a1 0 -15247502996.091112
Rp5_im_im_a1 0 x5_im_a1 1.693552678625933e-10
Cx6_re_a1 x6_re_a1 0 1.0
Gx6_re_a1 0 x6_re_a1 p1 0 0.1414213562373095
Fx6_re_a1 0 x6_re_a1 V1 7.0710678118654755
Rp6_re_re_a1 0 x6_re_a1 1.036160075862802e-10
Gp6_re_im_a1 0 x6_re_a1 x6_im_a1 0 8998832770.054014
Cx6_im_a1 x6_im_a1 0 1.0
Gp6_im_re_a1 0 x6_im_a1 x6_re_a1 0 -8998832770.054014
Rp6_im_im_a1 0 x6_im_a1 1.036160075862802e-10
Cx7_re_a1 x7_re_a1 0 1.0
Gx7_re_a1 0 x7_re_a1 p1 0 0.1414213562373095
Fx7_re_a1 0 x7_re_a1 V1 7.0710678118654755
Rp7_re_re_a1 0 x7_re_a1 1.24859515863571e-10
Gp7_re_im_a1 0 x7_re_a1 x7_im_a1 0 9408637032.62019
Cx7_im_a1 x7_im_a1 0 1.0
Gp7_im_re_a1 0 x7_im_a1 x7_re_a1 0 -9408637032.62019
Rp7_im_im_a1 0 x7_im_a1 1.24859515863571e-10
Cx8_a1 x8_a1 0 1.0
Gx8_a1 0 x8_a1 p1 0 0.07071067811865475
Fx8_a1 0 x8_a1 V1 3.5355339059327378
Rp8_a1 0 x8_a1 1.6767311224682652e-10
Cx9_a1 x9_a1 0 1.0
Gx9_a1 0 x9_a1 p1 0 0.07071067811865475
Fx9_a1 0 x9_a1 V1 3.5355339059327378
Rp9_a1 0 x9_a1 2.750900735393945e-10
Cx10_a1 x10_a1 0 1.0
Gx10_a1 0 x10_a1 p1 0 0.07071067811865475
Fx10_a1 0 x10_a1 V1 3.5355339059327378
Rp10_a1 0 x10_a1 1.32264240146516e-10
Cx11_a1 x11_a1 0 1.0
Gx11_a1 0 x11_a1 p1 0 0.07071067811865475
Fx11_a1 0 x11_a1 V1 3.5355339059327378
Rp11_a1 0 x11_a1 3.7845365270372834e-10
Cx12_a1 x12_a1 0 1.0
Gx12_a1 0 x12_a1 p1 0 0.07071067811865475
Fx12_a1 0 x12_a1 V1 3.5355339059327378
Rp12_a1 0 x12_a1 5.555020214406634e-10
Cx13_a1 x13_a1 0 1.0
Gx13_a1 0 x13_a1 p1 0 0.07071067811865475
Fx13_a1 0 x13_a1 V1 3.5355339059327378
Rp13_a1 0 x13_a1 1.6347849803771542e-10
Cx14_a1 x14_a1 0 1.0
Gx14_a1 0 x14_a1 p1 0 0.07071067811865475
Fx14_a1 0 x14_a1 V1 3.5355339059327378
Rp14_a1 0 x14_a1 1.7040371451462841e-10
Cx15_a1 x15_a1 0 1.0
Gx15_a1 0 x15_a1 p1 0 0.07071067811865475
Fx15_a1 0 x15_a1 V1 3.5355339059327378
Rp15_a1 0 x15_a1 1.8179569752681655e-10
Cx16_a1 x16_a1 0 1.0
Gx16_a1 0 x16_a1 p1 0 0.07071067811865475
Fx16_a1 0 x16_a1 V1 3.5355339059327378
Rp16_a1 0 x16_a1 1.918532353676509e-10
Cx17_a1 x17_a1 0 1.0
Gx17_a1 0 x17_a1 p1 0 0.07071067811865475
Fx17_a1 0 x17_a1 V1 3.5355339059327378
Rp17_a1 0 x17_a1 2.328543696094356e-10
Cx18_a1 x18_a1 0 1.0
Gx18_a1 0 x18_a1 p1 0 0.07071067811865475
Fx18_a1 0 x18_a1 V1 3.5355339059327378
Rp18_a1 0 x18_a1 9.348219196876375e-10
Cx19_a1 x19_a1 0 1.0
Gx19_a1 0 x19_a1 p1 0 0.07071067811865475
Fx19_a1 0 x19_a1 V1 3.5355339059327378
Rp19_a1 0 x19_a1 2.939588021230117e-10
Cx20_a1 x20_a1 0 1.0
Gx20_a1 0 x20_a1 p1 0 0.07071067811865475
Fx20_a1 0 x20_a1 V1 3.5355339059327378
Rp20_a1 0 x20_a1 2.683713947539702e-09
Cx21_a1 x21_a1 0 1.0
Gx21_a1 0 x21_a1 p1 0 0.07071067811865475
Fx21_a1 0 x21_a1 V1 3.5355339059327378
Rp21_a1 0 x21_a1 4.18236025275292e-10
Cx22_re_a1 x22_re_a1 0 1.0
Gx22_re_a1 0 x22_re_a1 p1 0 0.1414213562373095
Fx22_re_a1 0 x22_re_a1 V1 7.0710678118654755
Rp22_re_re_a1 0 x22_re_a1 2.7458072470285534e-09
Gp22_re_im_a1 0 x22_re_a1 x22_im_a1 0 8624170.806541923
Cx22_im_a1 x22_im_a1 0 1.0
Gp22_im_re_a1 0 x22_im_a1 x22_re_a1 0 -8624170.806541923
Rp22_im_im_a1 0 x22_im_a1 2.7458072470285534e-09
Cx23_a1 x23_a1 0 1.0
Gx23_a1 0 x23_a1 p1 0 0.07071067811865475
Fx23_a1 0 x23_a1 V1 3.5355339059327378
Rp23_a1 0 x23_a1 5.268957018332294e-10
Cx24_a1 x24_a1 0 1.0
Gx24_a1 0 x24_a1 p1 0 0.07071067811865475
Fx24_a1 0 x24_a1 V1 3.5355339059327378
Rp24_a1 0 x24_a1 5.524301402554093e-10
Cx25_a1 x25_a1 0 1.0
Gx25_a1 0 x25_a1 p1 0 0.07071067811865475
Fx25_a1 0 x25_a1 V1 3.5355339059327378
Rp25_a1 0 x25_a1 6.182755559671307e-10
Cx26_a1 x26_a1 0 1.0
Gx26_a1 0 x26_a1 p1 0 0.07071067811865475
Fx26_a1 0 x26_a1 V1 3.5355339059327378
Rp26_a1 0 x26_a1 8.241668156872392e-10
Cx27_a1 x27_a1 0 1.0
Gx27_a1 0 x27_a1 p1 0 0.07071067811865475
Fx27_a1 0 x27_a1 V1 3.5355339059327378
Rp27_a1 0 x27_a1 9.669163920651592e-10
Cx28_a1 x28_a1 0 1.0
Gx28_a1 0 x28_a1 p1 0 0.07071067811865475
Fx28_a1 0 x28_a1 V1 3.5355339059327378
Rp28_a1 0 x28_a1 8.959798579550586e-10
Cx29_a1 x29_a1 0 1.0
Gx29_a1 0 x29_a1 p1 0 0.07071067811865475
Fx29_a1 0 x29_a1 V1 3.5355339059327378
Rp29_a1 0 x29_a1 9.17915158018734e-10
Cx30_a1 x30_a1 0 1.0
Gx30_a1 0 x30_a1 p1 0 0.07071067811865475
Fx30_a1 0 x30_a1 V1 3.5355339059327378
Rp30_a1 0 x30_a1 9.360535841433275e-10
*
* Port network for port 2
V2 p2 s2 0
R2 s2 0 50.0
Gd2_1 0 s2 p1 0 9.139340114730375
Fd2_1 0 s2 V1 456.9670057365188
Gr1_2_1 0 s2 x1_a1 0 1.481725106108843e+21
Gr2_2_1 0 s2 x2_a1 0 -1.3746313002459616e+21
Gr3_re_2_1 0 s2 x3_re_a1 0 -5.579518855723414e+19
Gr3_im_2_1 0 s2 x3_im_a1 0 -4.201237858957923e+19
Gr4_re_2_1 0 s2 x4_re_a1 0 2.082051364339503e+21
Gr4_im_2_1 0 s2 x4_im_a1 0 -1.0758790695391131e+21
Gr5_re_2_1 0 s2 x5_re_a1 0 -3.643493811624126e+20
Gr5_im_2_1 0 s2 x5_im_a1 0 -3.983677947389462e+20
Gr6_re_2_1 0 s2 x6_re_a1 0 1.1644500728936309e+22
Gr6_im_2_1 0 s2 x6_im_a1 0 1.3147515722123687e+22
Gr7_re_2_1 0 s2 x7_re_a1 0 -8.998328188727025e+21
Gr7_im_2_1 0 s2 x7_im_a1 0 -1.2215749028137331e+22
Gr8_2_1 0 s2 x8_a1 0 -1.3864573146824264e+21
Gr9_2_1 0 s2 x9_a1 0 1.3216041520133822e+21
Gr10_2_1 0 s2 x10_a1 0 -9.40742189724822e+21
Gr11_2_1 0 s2 x11_a1 0 7.522334352859367e+20
Gr12_2_1 0 s2 x12_a1 0 1.2981289254098274e+20
Gr13_2_1 0 s2 x13_a1 0 -1.8776298593904403e+21
Gr14_2_1 0 s2 x14_a1 0 -1.1042550577297027e+21
Gr15_2_1 0 s2 x15_a1 0 -1.8340725835220877e+20
Gr16_2_1 0 s2 x16_a1 0 3.693978536330204e+20
Gr17_2_1 0 s2 x17_a1 0 1.2896123912887397e+21
Gr18_2_1 0 s2 x18_a1 0 -1.2686899295582657e+20
Gr19_2_1 0 s2 x19_a1 0 1.238650458832817e+21
Gr20_2_1 0 s2 x20_a1 0 -1.9224332432025403e+19
Gr21_2_1 0 s2 x21_a1 0 5.554335652164156e+20
Gr22_re_2_1 0 s2 x22_re_a1 0 -8.674074841518831e+18
Gr22_im_2_1 0 s2 x22_im_a1 0 -1.0309251812329853e+21
Gr23_2_1 0 s2 x23_a1 0 1.9162445771355822e+20
Gr24_2_1 0 s2 x24_a1 0 1.3589565794118155e+20
Gr25_2_1 0 s2 x25_a1 0 2.8854984635650474e+19
Gr26_2_1 0 s2 x26_a1 0 -1.096676434637051e+20
Gr27_2_1 0 s2 x27_a1 0 -1.2846718123474649e+20
Gr28_2_1 0 s2 x28_a1 0 -1.2318084851113316e+20
Gr29_2_1 0 s2 x29_a1 0 -1.255075606758101e+20
Gr30_2_1 0 s2 x30_a1 0 -1.2693624861850565e+20
Gd2_2 0 s2 p2 0 11.606081453875733
Fd2_2 0 s2 V2 580.3040726937867
Gr1_2_2 0 s2 x1_a2 0 1.8817171319698636e+21
Gr2_2_2 0 s2 x2_a2 0 -1.7457129792151987e+21
Gr3_re_2_2 0 s2 x3_re_a2 0 -7.085821757565059e+19
Gr3_im_2_2 0 s2 x3_im_a2 0 -5.33552127416794e+19
Gr4_re_2_2 0 s2 x4_re_a2 0 2.644153388161618e+21
Gr4_im_2_2 0 s2 x4_im_a2 0 -1.3663222800939273e+21
Gr5_re_2_2 0 s2 x5_re_a2 0 -4.6271236335086535e+20
Gr5_im_2_2 0 s2 x5_im_a2 0 -5.059184613614542e+20
Gr6_re_2_2 0 s2 x6_re_a2 0 1.4788098905019974e+22
Gr6_im_2_2 0 s2 x6_im_a2 0 1.6696977522389785e+22
Gr7_re_2_2 0 s2 x7_re_a2 0 -1.1427561197757285e+22
Gr7_im_2_2 0 s2 x7_im_a2 0 -1.5513660113365995e+22
Gr8_2_2 0 s2 x8_a2 0 -1.7607560647496014e+21
Gr9_2_2 0 s2 x9_a2 0 1.6783915271936292e+21
Gr10_2_2 0 s2 x10_a2 0 -1.1947112944314157e+22
Gr11_2_2 0 s2 x11_a2 0 9.553124541581383e+20
Gr12_2_2 0 s2 x12_a2 0 1.6485991819472342e+20
Gr13_2_2 0 s2 x13_a2 0 -2.3845346298990124e+21
Gr14_2_2 0 s2 x14_a2 0 -1.402366490113579e+21
Gr15_2_2 0 s2 x15_a2 0 -2.329216611638463e+20
Gr16_2_2 0 s2 x16_a2 0 4.6911722998232816e+20
Gr17_2_2 0 s2 x17_a2 0 1.6377670800919634e+21
Gr18_2_2 0 s2 x18_a2 0 -1.6111940595295126e+20
Gr19_2_2 0 s2 x19_a2 0 1.5730495906201582e+21
Gr20_2_2 0 s2 x20_a2 0 -2.441437412753752e+19
Gr21_2_2 0 s2 x21_a2 0 7.053850629691964e+20
Gr22_re_2_2 0 s2 x22_re_a2 0 -1.1015838397478134e+19
Gr22_im_2_2 0 s2 x22_im_a2 0 -1.3092439578833996e+21
Gr23_2_2 0 s2 x23_a2 0 2.4335599418041218e+20
Gr24_2_2 0 s2 x24_a2 0 1.7258446748701367e+20
Gr25_2_2 0 s2 x25_a2 0 3.6644847499345605e+19
Gr26_2_2 0 s2 x26_a2 0 -1.3927429871484979e+20
Gr27_2_2 0 s2 x27_a2 0 -1.631496452126144e+20
Gr28_2_2 0 s2 x28_a2 0 -1.564361837853527e+20
Gr29_2_2 0 s2 x29_a2 0 -1.5939126283859267e+20
Gr30_2_2 0 s2 x30_a2 0 -1.6120474230892705e+20
*
* State networks driven by port 2
Cx1_a2 x1_a2 0 1.0
Gx1_a2 0 x1_a2 p2 0 0.07071067811865475
Fx1_a2 0 x1_a2 V2 3.5355339059327378
Rp1_a2 0 x1_a2 3.105652024533764e-11
Cx2_a2 x2_a2 0 1.0
Gx2_a2 0 x2_a2 p2 0 0.07071067811865475
Fx2_a2 0 x2_a2 V2 3.5355339059327378
Rp2_a2 0 x2_a2 3.0782646267038896e-11
Cx3_re_a2 x3_re_a2 0 1.0
Gx3_re_a2 0 x3_re_a2 p2 0 0.1414213562373095
Fx3_re_a2 0 x3_re_a2 V2 7.0710678118654755
Rp3_re_re_a2 0 x3_re_a2 1.2814917329891254e-10
Gp3_re_im_a2 0 x3_re_a2 x3_im_a2 0 19207576919.03672
Cx3_im_a2 x3_im_a2 0 1.0
Gp3_im_re_a2 0 x3_im_a2 x3_re_a2 0 -19207576919.03672
Rp3_im_im_a2 0 x3_im_a2 1.2814917329891254e-10
Cx4_re_a2 x4_re_a2 0 1.0
Gx4_re_a2 0 x4_re_a2 p2 0 0.1414213562373095
Fx4_re_a2 0 x4_re_a2 V2 7.0710678118654755
Rp4_re_re_a2 0 x4_re_a2 1.0979763413557527e-10
Gp4_re_im_a2 0 x4_re_a2 x4_im_a2 0 14362319466.848879
Cx4_im_a2 x4_im_a2 0 1.0
Gp4_im_re_a2 0 x4_im_a2 x4_re_a2 0 -14362319466.848879
Rp4_im_im_a2 0 x4_im_a2 1.0979763413557527e-10
Cx5_re_a2 x5_re_a2 0 1.0
Gx5_re_a2 0 x5_re_a2 p2 0 0.1414213562373095
Fx5_re_a2 0 x5_re_a2 V2 7.0710678118654755
Rp5_re_re_a2 0 x5_re_a2 1.693552678625933e-10
Gp5_re_im_a2 0 x5_re_a2 x5_im_a2 0 15247502996.091112
Cx5_im_a2 x5_im_a2 0 1.0
Gp5_im_re_a2 0 x5_im_a2 x5_re_a2 0 -15247502996.091112
Rp5_im_im_a2 0 x5_im_a2 1.693552678625933e-10
Cx6_re_a2 x6_re_a2 0 1.0
Gx6_re_a2 0 x6_re_a2 p2 0 0.1414213562373095
Fx6_re_a2 0 x6_re_a2 V2 7.0710678118654755
Rp6_re_re_a2 0 x6_re_a2 1.036160075862802e-10
Gp6_re_im_a2 0 x6_re_a2 x6_im_a2 0 8998832770.054014
Cx6_im_a2 x6_im_a2 0 1.0
Gp6_im_re_a2 0 x6_im_a2 x6_re_a2 0 -8998832770.054014
Rp6_im_im_a2 0 x6_im_a2 1.036160075862802e-10
Cx7_re_a2 x7_re_a2 0 1.0
Gx7_re_a2 0 x7_re_a2 p2 0 0.1414213562373095
Fx7_re_a2 0 x7_re_a2 V2 7.0710678118654755
Rp7_re_re_a2 0 x7_re_a2 1.24859515863571e-10
Gp7_re_im_a2 0 x7_re_a2 x7_im_a2 0 9408637032.62019
Cx7_im_a2 x7_im_a2 0 1.0
Gp7_im_re_a2 0 x7_im_a2 x7_re_a2 0 -9408637032.62019
Rp7_im_im_a2 0 x7_im_a2 1.24859515863571e-10
Cx8_a2 x8_a2 0 1.0
Gx8_a2 0 x8_a2 p2 0 0.07071067811865475
Fx8_a2 0 x8_a2 V2 3.5355339059327378
Rp8_a2 0 x8_a2 1.6767311224682652e-10
Cx9_a2 x9_a2 0 1.0
Gx9_a2 0 x9_a2 p2 0 0.07071067811865475
Fx9_a2 0 x9_a2 V2 3.5355339059327378
Rp9_a2 0 x9_a2 2.750900735393945e-10
Cx10_a2 x10_a2 0 1.0
Gx10_a2 0 x10_a2 p2 0 0.07071067811865475
Fx10_a2 0 x10_a2 V2 3.5355339059327378
Rp10_a2 0 x10_a2 1.32264240146516e-10
Cx11_a2 x11_a2 0 1.0
Gx11_a2 0 x11_a2 p2 0 0.07071067811865475
Fx11_a2 0 x11_a2 V2 3.5355339059327378
Rp11_a2 0 x11_a2 3.7845365270372834e-10
Cx12_a2 x12_a2 0 1.0
Gx12_a2 0 x12_a2 p2 0 0.07071067811865475
Fx12_a2 0 x12_a2 V2 3.5355339059327378
Rp12_a2 0 x12_a2 5.555020214406634e-10
Cx13_a2 x13_a2 0 1.0
Gx13_a2 0 x13_a2 p2 0 0.07071067811865475
Fx13_a2 0 x13_a2 V2 3.5355339059327378
Rp13_a2 0 x13_a2 1.6347849803771542e-10
Cx14_a2 x14_a2 0 1.0
Gx14_a2 0 x14_a2 p2 0 0.07071067811865475
Fx14_a2 0 x14_a2 V2 3.5355339059327378
Rp14_a2 0 x14_a2 1.7040371451462841e-10
Cx15_a2 x15_a2 0 1.0
Gx15_a2 0 x15_a2 p2 0 0.07071067811865475
Fx15_a2 0 x15_a2 V2 3.5355339059327378
Rp15_a2 0 x15_a2 1.8179569752681655e-10
Cx16_a2 x16_a2 0 1.0
Gx16_a2 0 x16_a2 p2 0 0.07071067811865475
Fx16_a2 0 x16_a2 V2 3.5355339059327378
Rp16_a2 0 x16_a2 1.918532353676509e-10
Cx17_a2 x17_a2 0 1.0
Gx17_a2 0 x17_a2 p2 0 0.07071067811865475
Fx17_a2 0 x17_a2 V2 3.5355339059327378
Rp17_a2 0 x17_a2 2.328543696094356e-10
Cx18_a2 x18_a2 0 1.0
Gx18_a2 0 x18_a2 p2 0 0.07071067811865475
Fx18_a2 0 x18_a2 V2 3.5355339059327378
Rp18_a2 0 x18_a2 9.348219196876375e-10
Cx19_a2 x19_a2 0 1.0
Gx19_a2 0 x19_a2 p2 0 0.07071067811865475
Fx19_a2 0 x19_a2 V2 3.5355339059327378
Rp19_a2 0 x19_a2 2.939588021230117e-10
Cx20_a2 x20_a2 0 1.0
Gx20_a2 0 x20_a2 p2 0 0.07071067811865475
Fx20_a2 0 x20_a2 V2 3.5355339059327378
Rp20_a2 0 x20_a2 2.683713947539702e-09
Cx21_a2 x21_a2 0 1.0
Gx21_a2 0 x21_a2 p2 0 0.07071067811865475
Fx21_a2 0 x21_a2 V2 3.5355339059327378
Rp21_a2 0 x21_a2 4.18236025275292e-10
Cx22_re_a2 x22_re_a2 0 1.0
Gx22_re_a2 0 x22_re_a2 p2 0 0.1414213562373095
Fx22_re_a2 0 x22_re_a2 V2 7.0710678118654755
Rp22_re_re_a2 0 x22_re_a2 2.7458072470285534e-09
Gp22_re_im_a2 0 x22_re_a2 x22_im_a2 0 8624170.806541923
Cx22_im_a2 x22_im_a2 0 1.0
Gp22_im_re_a2 0 x22_im_a2 x22_re_a2 0 -8624170.806541923
Rp22_im_im_a2 0 x22_im_a2 2.7458072470285534e-09
Cx23_a2 x23_a2 0 1.0
Gx23_a2 0 x23_a2 p2 0 0.07071067811865475
Fx23_a2 0 x23_a2 V2 3.5355339059327378
Rp23_a2 0 x23_a2 5.268957018332294e-10
Cx24_a2 x24_a2 0 1.0
Gx24_a2 0 x24_a2 p2 0 0.07071067811865475
Fx24_a2 0 x24_a2 V2 3.5355339059327378
Rp24_a2 0 x24_a2 5.524301402554093e-10
Cx25_a2 x25_a2 0 1.0
Gx25_a2 0 x25_a2 p2 0 0.07071067811865475
Fx25_a2 0 x25_a2 V2 3.5355339059327378
Rp25_a2 0 x25_a2 6.182755559671307e-10
Cx26_a2 x26_a2 0 1.0
Gx26_a2 0 x26_a2 p2 0 0.07071067811865475
Fx26_a2 0 x26_a2 V2 3.5355339059327378
Rp26_a2 0 x26_a2 8.241668156872392e-10
Cx27_a2 x27_a2 0 1.0
Gx27_a2 0 x27_a2 p2 0 0.07071067811865475
Fx27_a2 0 x27_a2 V2 3.5355339059327378
Rp27_a2 0 x27_a2 9.669163920651592e-10
Cx28_a2 x28_a2 0 1.0
Gx28_a2 0 x28_a2 p2 0 0.07071067811865475
Fx28_a2 0 x28_a2 V2 3.5355339059327378
Rp28_a2 0 x28_a2 8.959798579550586e-10
Cx29_a2 x29_a2 0 1.0
Gx29_a2 0 x29_a2 p2 0 0.07071067811865475
Fx29_a2 0 x29_a2 V2 3.5355339059327378
Rp29_a2 0 x29_a2 9.17915158018734e-10
Cx30_a2 x30_a2 0 1.0
Gx30_a2 0 x30_a2 p2 0 0.07071067811865475
Fx30_a2 0 x30_a2 V2 3.5355339059327378
Rp30_a2 0 x30_a2 9.360535841433275e-10
.ENDS s_equivalent
