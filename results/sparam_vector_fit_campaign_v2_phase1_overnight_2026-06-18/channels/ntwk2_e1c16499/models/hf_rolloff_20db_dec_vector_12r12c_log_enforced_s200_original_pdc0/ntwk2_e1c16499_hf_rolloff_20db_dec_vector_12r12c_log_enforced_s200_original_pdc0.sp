* EQUIVALENT CIRCUIT FOR VECTOR FITTED S-MATRIX
* Created using scikit-rf vectorFitting.py
*
.SUBCKT s_equivalent p1 p2
*
* Port network for port 1
V1 p1 s1 0
R1 s1 0 50.0
Gd1_1 0 s1 p1 0 -1.3985521250537323
Fd1_1 0 s1 V1 -69.92760625268662
Gr1_1_1 0 s1 x1_a1 0 978908146731264.4
Gr2_1_1 0 s1 x2_a1 0 -7.629402292773867e+16
Gr3_1_1 0 s1 x3_a1 0 8.004166790647475e+16
Gr4_1_1 0 s1 x4_a1 0 -2.594082247711274e+18
Gr5_1_1 0 s1 x5_a1 0 2.663292406318997e+18
Gr6_1_1 0 s1 x6_a1 0 1.2846844643220025e+20
Gr7_1_1 0 s1 x7_a1 0 -1.2718438518299568e+20
Gr8_1_1 0 s1 x8_a1 0 6.261309450761376e+20
Gr9_1_1 0 s1 x9_a1 0 -5.7903090652185166e+20
Gr10_1_1 0 s1 x10_a1 0 -1.9234229627300847e+22
Gr11_re_1_1 0 s1 x11_re_a1 0 6.028612359081101e+21
Gr11_im_1_1 0 s1 x11_im_a1 0 9.53309878255889e+21
Gr12_re_1_1 0 s1 x12_re_a1 0 -7.755890656058743e+21
Gr12_im_1_1 0 s1 x12_im_a1 0 -1.522985809159187e+23
Gr13_1_1 0 s1 x13_a1 0 5.735239102526149e+22
Gr14_re_1_1 0 s1 x14_re_a1 0 4.505731516746195e+21
Gr14_im_1_1 0 s1 x14_im_a1 0 -1.0377330521826822e+22
Gr15_1_1 0 s1 x15_a1 0 -1.273701111735542e+22
Gr16_re_1_1 0 s1 x16_re_a1 0 -1.5298692878737519e+22
Gr16_im_1_1 0 s1 x16_im_a1 0 1.147094551798256e+22
Gr17_re_1_1 0 s1 x17_re_a1 0 -1.0357353407459935e+22
Gr17_im_1_1 0 s1 x17_im_a1 0 1.4515071470600402e+22
Gr18_re_1_1 0 s1 x18_re_a1 0 1.8988306753683894e+22
Gr18_im_1_1 0 s1 x18_im_a1 0 -5.131994909176357e+21
Gr19_re_1_1 0 s1 x19_re_a1 0 -1.0489504305861238e+22
Gr19_im_1_1 0 s1 x19_im_a1 0 -1.3727943720271484e+22
Gr20_re_1_1 0 s1 x20_re_a1 0 -2.84621180706554e+21
Gr20_im_1_1 0 s1 x20_im_a1 0 1.288668066003121e+22
Gr21_re_1_1 0 s1 x21_re_a1 0 6.702041627955276e+21
Gr21_im_1_1 0 s1 x21_im_a1 0 -1.1735294732977534e+21
Gr22_re_1_1 0 s1 x22_re_a1 0 -2.0331780382326152e+21
Gr22_im_1_1 0 s1 x22_im_a1 0 -1.690081865137525e+21
Gr23_re_1_1 0 s1 x23_re_a1 0 4.321289471404867e+19
Gr23_im_1_1 0 s1 x23_im_a1 0 2.5175238782003764e+20
Gr24_re_1_1 0 s1 x24_re_a1 0 -2.0187785038507262e+20
Gr24_im_1_1 0 s1 x24_im_a1 0 -1.2255187036879826e+20
Gd1_2 0 s1 p2 0 1.706583633900348
Fd1_2 0 s1 V2 85.3291816950174
Gr1_1_2 0 s1 x1_a2 0 -1210225548993250.5
Gr2_1_2 0 s1 x2_a2 0 1.0412613221186147e+17
Gr3_1_2 0 s1 x3_a2 0 -1.0941451268109643e+17
Gr4_1_2 0 s1 x4_a2 0 3.7688785853975977e+18
Gr5_1_2 0 s1 x5_a2 0 -3.870636736589503e+18
Gr6_1_2 0 s1 x6_a2 0 -1.900528606465904e+20
Gr7_1_2 0 s1 x7_a2 0 1.8814989264751998e+20
Gr8_1_2 0 s1 x8_a2 0 -9.236284128448256e+20
Gr9_1_2 0 s1 x9_a2 0 8.543057775676879e+20
Gr10_1_2 0 s1 x10_a2 0 2.8030858693282267e+22
Gr11_re_1_2 0 s1 x11_re_a2 0 -8.809627782917626e+21
Gr11_im_1_2 0 s1 x11_im_a2 0 -1.386525523199344e+22
Gr12_re_1_2 0 s1 x12_re_a2 0 1.1370042975078289e+22
Gr12_im_1_2 0 s1 x12_im_a2 0 2.1828905201262954e+23
Gr13_1_2 0 s1 x13_a2 0 -8.269714524860393e+22
Gr14_re_1_2 0 s1 x14_re_a2 0 -6.379024014871538e+21
Gr14_im_1_2 0 s1 x14_im_a2 0 1.5127870204593886e+22
Gr15_1_2 0 s1 x15_a2 0 1.8623355585851428e+22
Gr16_re_1_2 0 s1 x16_re_a2 0 2.1561660116962566e+22
Gr16_im_1_2 0 s1 x16_im_a2 0 -1.6825693839985511e+22
Gr17_re_1_2 0 s1 x17_re_a2 0 1.4682725247816997e+22
Gr17_im_1_2 0 s1 x17_im_a2 0 -2.068721462151642e+22
Gr18_re_1_2 0 s1 x18_re_a2 0 -2.6873560815630966e+22
Gr18_im_1_2 0 s1 x18_im_a2 0 7.422690611383536e+21
Gr19_re_1_2 0 s1 x19_re_a2 0 1.4962848264867866e+22
Gr19_im_1_2 0 s1 x19_im_a2 0 1.9276752368857063e+22
Gr20_re_1_2 0 s1 x20_re_a2 0 3.8586004493371357e+21
Gr20_im_1_2 0 s1 x20_im_a2 0 -1.8203127222185056e+22
Gr21_re_1_2 0 s1 x21_re_a2 0 -9.417305556324992e+21
Gr21_im_1_2 0 s1 x21_im_a2 0 1.7365582944854265e+21
Gr22_re_1_2 0 s1 x22_re_a2 0 2.8800054361052566e+21
Gr22_im_1_2 0 s1 x22_im_a2 0 2.3497907732722698e+21
Gr23_re_1_2 0 s1 x23_re_a2 0 -6.389655497642078e+19
Gr23_im_1_2 0 s1 x23_im_a2 0 -3.5303838871520884e+20
Gr24_re_1_2 0 s1 x24_re_a2 0 2.846641990854371e+20
Gr24_im_1_2 0 s1 x24_im_a2 0 1.698639112495589e+20
*
* State networks driven by port 1
Cx1_a1 x1_a1 0 1.0
Gx1_a1 0 x1_a1 p1 0 0.07071067811865475
Fx1_a1 0 x1_a1 V1 3.5355339059327378
Rp1_a1 0 x1_a1 4.4630940096475407e-14
Cx2_a1 x2_a1 0 1.0
Gx2_a1 0 x2_a1 p1 0 0.07071067811865475
Fx2_a1 0 x2_a1 V1 3.5355339059327378
Rp2_a1 0 x2_a1 2.6823272878894216e-13
Cx3_a1 x3_a1 0 1.0
Gx3_a1 0 x3_a1 p1 0 0.07071067811865475
Fx3_a1 0 x3_a1 V1 3.5355339059327378
Rp3_a1 0 x3_a1 2.730546259065842e-13
Cx4_a1 x4_a1 0 1.0
Gx4_a1 0 x4_a1 p1 0 0.07071067811865475
Fx4_a1 0 x4_a1 V1 3.5355339059327378
Rp4_a1 0 x4_a1 6.350630740293813e-13
Cx5_a1 x5_a1 0 1.0
Gx5_a1 0 x5_a1 p1 0 0.07071067811865475
Fx5_a1 0 x5_a1 V1 3.5355339059327378
Rp5_a1 0 x5_a1 6.392035722775283e-13
Cx6_a1 x6_a1 0 1.0
Gx6_a1 0 x6_a1 p1 0 0.07071067811865475
Fx6_a1 0 x6_a1 V1 3.5355339059327378
Rp6_a1 0 x6_a1 1.2145349746803566e-12
Cx7_a1 x7_a1 0 1.0
Gx7_a1 0 x7_a1 p1 0 0.07071067811865475
Fx7_a1 0 x7_a1 V1 3.5355339059327378
Rp7_a1 0 x7_a1 1.2120861529790142e-12
Cx8_a1 x8_a1 0 1.0
Gx8_a1 0 x8_a1 p1 0 0.07071067811865475
Fx8_a1 0 x8_a1 V1 3.5355339059327378
Rp8_a1 0 x8_a1 2.1799702018089484e-12
Cx9_a1 x9_a1 0 1.0
Gx9_a1 0 x9_a1 p1 0 0.07071067811865475
Fx9_a1 0 x9_a1 V1 3.5355339059327378
Rp9_a1 0 x9_a1 2.1550615550265876e-12
Cx10_a1 x10_a1 0 1.0
Gx10_a1 0 x10_a1 p1 0 0.07071067811865475
Fx10_a1 0 x10_a1 V1 3.5355339059327378
Rp10_a1 0 x10_a1 3.852200708503856e-12
Cx11_re_a1 x11_re_a1 0 1.0
Gx11_re_a1 0 x11_re_a1 p1 0 0.1414213562373095
Fx11_re_a1 0 x11_re_a1 V1 7.0710678118654755
Rp11_re_re_a1 0 x11_re_a1 3.973889018632521e-12
Gp11_re_im_a1 0 x11_re_a1 x11_im_a1 0 22363223894.888424
Cx11_im_a1 x11_im_a1 0 1.0
Gp11_im_re_a1 0 x11_im_a1 x11_re_a1 0 -22363223894.888424
Rp11_im_im_a1 0 x11_im_a1 3.973889018632521e-12
Cx12_re_a1 x12_re_a1 0 1.0
Gx12_re_a1 0 x12_re_a1 p1 0 0.1414213562373095
Fx12_re_a1 0 x12_re_a1 V1 7.0710678118654755
Rp12_re_re_a1 0 x12_re_a1 7.793184146212855e-12
Gp12_re_im_a1 0 x12_re_a1 x12_im_a1 0 9886185359.4414
Cx12_im_a1 x12_im_a1 0 1.0
Gp12_im_re_a1 0 x12_im_a1 x12_re_a1 0 -9886185359.4414
Rp12_im_im_a1 0 x12_im_a1 7.793184146212855e-12
Cx13_a1 x13_a1 0 1.0
Gx13_a1 0 x13_a1 p1 0 0.07071067811865475
Fx13_a1 0 x13_a1 V1 3.5355339059327378
Rp13_a1 0 x13_a1 6.027580521771517e-12
Cx14_re_a1 x14_re_a1 0 1.0
Gx14_re_a1 0 x14_re_a1 p1 0 0.1414213562373095
Fx14_re_a1 0 x14_re_a1 V1 7.0710678118654755
Rp14_re_re_a1 0 x14_re_a1 1.3012613550079421e-11
Gp14_re_im_a1 0 x14_re_a1 x14_im_a1 0 55538933853.80004
Cx14_im_a1 x14_im_a1 0 1.0
Gp14_im_re_a1 0 x14_im_a1 x14_re_a1 0 -55538933853.80004
Rp14_im_im_a1 0 x14_im_a1 1.3012613550079421e-11
Cx15_a1 x15_a1 0 1.0
Gx15_a1 0 x15_a1 p1 0 0.07071067811865475
Fx15_a1 0 x15_a1 V1 3.5355339059327378
Rp15_a1 0 x15_a1 8.385580341283459e-12
Cx16_re_a1 x16_re_a1 0 1.0
Gx16_re_a1 0 x16_re_a1 p1 0 0.1414213562373095
Fx16_re_a1 0 x16_re_a1 V1 7.0710678118654755
Rp16_re_re_a1 0 x16_re_a1 1.1407048462801193e-11
Gp16_re_im_a1 0 x16_re_a1 x16_im_a1 0 45606235437.41829
Cx16_im_a1 x16_im_a1 0 1.0
Gp16_im_re_a1 0 x16_im_a1 x16_re_a1 0 -45606235437.41829
Rp16_im_im_a1 0 x16_im_a1 1.1407048462801193e-11
Cx17_re_a1 x17_re_a1 0 1.0
Gx17_re_a1 0 x17_re_a1 p1 0 0.1414213562373095
Fx17_re_a1 0 x17_re_a1 V1 7.0710678118654755
Rp17_re_re_a1 0 x17_re_a1 1.852280317388511e-11
Gp17_re_im_a1 0 x17_re_a1 x17_im_a1 0 65899210393.223076
Cx17_im_a1 x17_im_a1 0 1.0
Gp17_im_re_a1 0 x17_im_a1 x17_re_a1 0 -65899210393.223076
Rp17_im_im_a1 0 x17_im_a1 1.852280317388511e-11
Cx18_re_a1 x18_re_a1 0 1.0
Gx18_re_a1 0 x18_re_a1 p1 0 0.1414213562373095
Fx18_re_a1 0 x18_re_a1 V1 7.0710678118654755
Rp18_re_re_a1 0 x18_re_a1 2.3270679923416994e-11
Gp18_re_im_a1 0 x18_re_a1 x18_im_a1 0 70701709596.66743
Cx18_im_a1 x18_im_a1 0 1.0
Gp18_im_re_a1 0 x18_im_a1 x18_re_a1 0 -70701709596.66743
Rp18_im_im_a1 0 x18_im_a1 2.3270679923416994e-11
Cx19_re_a1 x19_re_a1 0 1.0
Gx19_re_a1 0 x19_re_a1 p1 0 0.1414213562373095
Fx19_re_a1 0 x19_re_a1 V1 7.0710678118654755
Rp19_re_re_a1 0 x19_re_a1 3.4802215599217653e-11
Gp19_re_im_a1 0 x19_re_a1 x19_im_a1 0 73499212435.46643
Cx19_im_a1 x19_im_a1 0 1.0
Gp19_im_re_a1 0 x19_im_a1 x19_re_a1 0 -73499212435.46643
Rp19_im_im_a1 0 x19_im_a1 3.4802215599217653e-11
Cx20_re_a1 x20_re_a1 0 1.0
Gx20_re_a1 0 x20_re_a1 p1 0 0.1414213562373095
Fx20_re_a1 0 x20_re_a1 V1 7.0710678118654755
Rp20_re_re_a1 0 x20_re_a1 4.919279295748042e-11
Gp20_re_im_a1 0 x20_re_a1 x20_im_a1 0 74629724773.38298
Cx20_im_a1 x20_im_a1 0 1.0
Gp20_im_re_a1 0 x20_im_a1 x20_re_a1 0 -74629724773.38298
Rp20_im_im_a1 0 x20_im_a1 4.919279295748042e-11
Cx21_re_a1 x21_re_a1 0 1.0
Gx21_re_a1 0 x21_re_a1 p1 0 0.1414213562373095
Fx21_re_a1 0 x21_re_a1 V1 7.0710678118654755
Rp21_re_re_a1 0 x21_re_a1 8.75440977265228e-11
Gp21_re_im_a1 0 x21_re_a1 x21_im_a1 0 74382551668.83495
Cx21_im_a1 x21_im_a1 0 1.0
Gp21_im_re_a1 0 x21_im_a1 x21_re_a1 0 -74382551668.83495
Rp21_im_im_a1 0 x21_im_a1 8.75440977265228e-11
Cx22_re_a1 x22_re_a1 0 1.0
Gx22_re_a1 0 x22_re_a1 p1 0 0.1414213562373095
Fx22_re_a1 0 x22_re_a1 V1 7.0710678118654755
Rp22_re_re_a1 0 x22_re_a1 1.7031651609643428e-10
Gp22_re_im_a1 0 x22_re_a1 x22_im_a1 0 73514649466.7239
Cx22_im_a1 x22_im_a1 0 1.0
Gp22_im_re_a1 0 x22_im_a1 x22_re_a1 0 -73514649466.7239
Rp22_im_im_a1 0 x22_im_a1 1.7031651609643428e-10
Cx23_re_a1 x23_re_a1 0 1.0
Gx23_re_a1 0 x23_re_a1 p1 0 0.1414213562373095
Fx23_re_a1 0 x23_re_a1 V1 7.0710678118654755
Rp23_re_re_a1 0 x23_re_a1 8.103997860421194e-10
Gp23_re_im_a1 0 x23_re_a1 x23_im_a1 0 71777301961.28047
Cx23_im_a1 x23_im_a1 0 1.0
Gp23_im_re_a1 0 x23_im_a1 x23_re_a1 0 -71777301961.28047
Rp23_im_im_a1 0 x23_im_a1 8.103997860421194e-10
Cx24_re_a1 x24_re_a1 0 1.0
Gx24_re_a1 0 x24_re_a1 p1 0 0.1414213562373095
Fx24_re_a1 0 x24_re_a1 V1 7.0710678118654755
Rp24_re_re_a1 0 x24_re_a1 3.823462806643114e-06
Gp24_re_im_a1 0 x24_re_a1 x24_im_a1 0 62894738064.385994
Cx24_im_a1 x24_im_a1 0 1.0
Gp24_im_re_a1 0 x24_im_a1 x24_re_a1 0 -62894738064.385994
Rp24_im_im_a1 0 x24_im_a1 3.823462806643114e-06
*
* Port network for port 2
V2 p2 s2 0
R2 s2 0 50.0
Gd2_1 0 s2 p1 0 1.706583633900348
Fd2_1 0 s2 V1 85.3291816950174
Gr1_2_1 0 s2 x1_a1 0 -1210225518497744.2
Gr2_2_1 0 s2 x2_a1 0 1.0412610602757072e+17
Gr3_2_1 0 s2 x3_a1 0 -1.0941448463597763e+17
Gr4_2_1 0 s2 x4_a1 0 3.7688765265626173e+18
Gr5_2_1 0 s2 x5_a1 0 -3.8706346128405504e+18
Gr6_2_1 0 s2 x6_a1 0 -1.900527239542778e+20
Gr7_2_1 0 s2 x7_a1 0 1.8814975736176325e+20
Gr8_2_1 0 s2 x8_a1 0 -9.236277859250345e+20
Gr9_2_1 0 s2 x9_a1 0 8.543051959078603e+20
Gr10_2_1 0 s2 x10_a1 0 2.803084156302174e+22
Gr11_re_2_1 0 s2 x11_re_a1 0 -8.809622472976067e+21
Gr11_im_2_1 0 s2 x11_im_a1 0 -1.3865246748080207e+22
Gr12_re_2_1 0 s2 x12_re_a1 0 1.1370039596337127e+22
Gr12_im_2_1 0 s2 x12_im_a1 0 2.182888742797421e+23
Gr13_2_1 0 s2 x13_a1 0 -8.269708749357588e+22
Gr14_re_2_1 0 s2 x14_re_a1 0 -6.379018478269693e+21
Gr14_im_2_1 0 s2 x14_im_a1 0 1.5127867387236422e+22
Gr15_2_1 0 s2 x15_a1 0 1.8623349400191178e+22
Gr16_re_2_1 0 s2 x16_re_a1 0 2.1561633943658605e+22
Gr16_im_2_1 0 s2 x16_im_a1 0 -1.6825693433074633e+22
Gr17_re_2_1 0 s2 x17_re_a1 0 1.468271051654074e+22
Gr17_im_2_1 0 s2 x17_im_a1 0 -2.068719549561566e+22
Gr18_re_2_1 0 s2 x18_re_a1 0 -2.6873531092129683e+22
Gr18_im_2_1 0 s2 x18_im_a1 0 7.422686934842094e+21
Gr19_re_2_1 0 s2 x19_re_a1 0 1.4962835466666788e+22
Gr19_im_2_1 0 s2 x19_im_a1 0 1.927672596695573e+22
Gr20_re_2_1 0 s2 x20_re_a1 0 3.8585903822402e+21
Gr20_im_2_1 0 s2 x20_im_a1 0 -1.820310584072437e+22
Gr21_re_2_1 0 s2 x21_re_a1 0 -9.417292745906394e+21
Gr21_im_2_1 0 s2 x21_im_a1 0 1.736559041307334e+21
Gr22_re_2_1 0 s2 x22_re_a1 0 2.880002343919379e+21
Gr22_im_2_1 0 s2 x22_im_a1 0 2.3497866693278585e+21
Gr23_re_2_1 0 s2 x23_re_a1 0 -6.3896583432049705e+19
Gr23_im_2_1 0 s2 x23_im_a1 0 -3.530378809337933e+20
Gr24_re_2_1 0 s2 x24_re_a1 0 2.846638449627556e+20
Gr24_im_2_1 0 s2 x24_im_a1 0 1.6986359324568188e+20
Gd2_2 0 s2 p2 0 -0.7501562756459161
Fd2_2 0 s2 V2 -37.507813782295806
Gr1_2_2 0 s2 x1_a2 0 519096441911370.94
Gr2_2_2 0 s2 x2_a2 0 -3.6732055880116744e+16
Gr3_2_2 0 s2 x3_a2 0 3.847041110929791e+16
Gr4_2_2 0 s2 x4_a2 0 -1.1621044865373873e+18
Gr5_2_2 0 s2 x5_a2 0 1.1926516238975813e+18
Gr6_2_2 0 s2 x6_a2 0 5.6256850772895924e+19
Gr7_2_2 0 s2 x7_a2 0 -5.569583771013415e+19
Gr8_2_2 0 s2 x8_a2 0 2.7518479839216183e+20
Gr9_2_2 0 s2 x9_a2 0 -2.544250744504853e+20
Gr10_2_2 0 s2 x10_a2 0 -8.583276386267425e+21
Gr11_re_2_2 0 s2 x11_re_a2 0 2.6812033002521913e+21
Gr11_im_2_2 0 s2 x11_im_a2 0 4.2646737323333654e+21
Gr12_re_2_2 0 s2 x12_re_a2 0 -3.4360764436452847e+21
Gr12_im_2_2 0 s2 x12_im_a2 0 -6.935495227161521e+22
Gr13_2_2 0 s2 x13_a2 0 2.5929688146741723e+22
Gr14_re_2_2 0 s2 x14_re_a2 0 2.0817982660823613e+21
Gr14_im_2_2 0 s2 x14_im_a2 0 -4.628720180592118e+21
Gr15_2_2 0 s2 x15_a2 0 -5.658926665627379e+21
Gr16_re_2_2 0 s2 x16_re_a2 0 -7.106244923299444e+21
Gr16_im_2_2 0 s2 x16_im_a2 0 5.077044117624281e+21
Gr17_re_2_2 0 s2 x17_re_a2 0 -4.778426085121025e+21
Gr17_im_2_2 0 s2 x17_im_a2 0 6.65470146568202e+21
Gr18_re_2_2 0 s2 x18_re_a2 0 8.777513062029991e+21
Gr18_im_2_2 0 s2 x18_im_a2 0 -2.3115149480968771e+21
Gr19_re_2_2 0 s2 x19_re_a2 0 -4.804088545294257e+21
Gr19_im_2_2 0 s2 x19_im_a2 0 -6.403871916412724e+21
Gr20_re_2_2 0 s2 x20_re_a2 0 -1.3804171487746164e+21
Gr20_im_2_2 0 s2 x20_im_a2 0 5.970351381846951e+21
Gr21_re_2_2 0 s2 x21_re_a2 0 3.1240071837685284e+21
Gr21_im_2_2 0 s2 x21_im_a2 0 -5.135678734806876e+20
Gr22_re_2_2 0 s2 x22_re_a2 0 -9.388970755745596e+20
Gr22_im_2_2 0 s2 x22_im_a2 0 -7.97347218929944e+20
Gr23_re_2_2 0 s2 x23_re_a2 0 1.8929551775851663e+19
Gr23_im_2_2 0 s2 x23_im_a2 0 1.1761982894567318e+20
Gr24_re_2_2 0 s2 x24_re_a2 0 -9.372026453570021e+19
Gr24_im_2_2 0 s2 x24_im_a2 0 -5.801818336552898e+19
*
* State networks driven by port 2
Cx1_a2 x1_a2 0 1.0
Gx1_a2 0 x1_a2 p2 0 0.07071067811865475
Fx1_a2 0 x1_a2 V2 3.5355339059327378
Rp1_a2 0 x1_a2 4.4630940096475407e-14
Cx2_a2 x2_a2 0 1.0
Gx2_a2 0 x2_a2 p2 0 0.07071067811865475
Fx2_a2 0 x2_a2 V2 3.5355339059327378
Rp2_a2 0 x2_a2 2.6823272878894216e-13
Cx3_a2 x3_a2 0 1.0
Gx3_a2 0 x3_a2 p2 0 0.07071067811865475
Fx3_a2 0 x3_a2 V2 3.5355339059327378
Rp3_a2 0 x3_a2 2.730546259065842e-13
Cx4_a2 x4_a2 0 1.0
Gx4_a2 0 x4_a2 p2 0 0.07071067811865475
Fx4_a2 0 x4_a2 V2 3.5355339059327378
Rp4_a2 0 x4_a2 6.350630740293813e-13
Cx5_a2 x5_a2 0 1.0
Gx5_a2 0 x5_a2 p2 0 0.07071067811865475
Fx5_a2 0 x5_a2 V2 3.5355339059327378
Rp5_a2 0 x5_a2 6.392035722775283e-13
Cx6_a2 x6_a2 0 1.0
Gx6_a2 0 x6_a2 p2 0 0.07071067811865475
Fx6_a2 0 x6_a2 V2 3.5355339059327378
Rp6_a2 0 x6_a2 1.2145349746803566e-12
Cx7_a2 x7_a2 0 1.0
Gx7_a2 0 x7_a2 p2 0 0.07071067811865475
Fx7_a2 0 x7_a2 V2 3.5355339059327378
Rp7_a2 0 x7_a2 1.2120861529790142e-12
Cx8_a2 x8_a2 0 1.0
Gx8_a2 0 x8_a2 p2 0 0.07071067811865475
Fx8_a2 0 x8_a2 V2 3.5355339059327378
Rp8_a2 0 x8_a2 2.1799702018089484e-12
Cx9_a2 x9_a2 0 1.0
Gx9_a2 0 x9_a2 p2 0 0.07071067811865475
Fx9_a2 0 x9_a2 V2 3.5355339059327378
Rp9_a2 0 x9_a2 2.1550615550265876e-12
Cx10_a2 x10_a2 0 1.0
Gx10_a2 0 x10_a2 p2 0 0.07071067811865475
Fx10_a2 0 x10_a2 V2 3.5355339059327378
Rp10_a2 0 x10_a2 3.852200708503856e-12
Cx11_re_a2 x11_re_a2 0 1.0
Gx11_re_a2 0 x11_re_a2 p2 0 0.1414213562373095
Fx11_re_a2 0 x11_re_a2 V2 7.0710678118654755
Rp11_re_re_a2 0 x11_re_a2 3.973889018632521e-12
Gp11_re_im_a2 0 x11_re_a2 x11_im_a2 0 22363223894.888424
Cx11_im_a2 x11_im_a2 0 1.0
Gp11_im_re_a2 0 x11_im_a2 x11_re_a2 0 -22363223894.888424
Rp11_im_im_a2 0 x11_im_a2 3.973889018632521e-12
Cx12_re_a2 x12_re_a2 0 1.0
Gx12_re_a2 0 x12_re_a2 p2 0 0.1414213562373095
Fx12_re_a2 0 x12_re_a2 V2 7.0710678118654755
Rp12_re_re_a2 0 x12_re_a2 7.793184146212855e-12
Gp12_re_im_a2 0 x12_re_a2 x12_im_a2 0 9886185359.4414
Cx12_im_a2 x12_im_a2 0 1.0
Gp12_im_re_a2 0 x12_im_a2 x12_re_a2 0 -9886185359.4414
Rp12_im_im_a2 0 x12_im_a2 7.793184146212855e-12
Cx13_a2 x13_a2 0 1.0
Gx13_a2 0 x13_a2 p2 0 0.07071067811865475
Fx13_a2 0 x13_a2 V2 3.5355339059327378
Rp13_a2 0 x13_a2 6.027580521771517e-12
Cx14_re_a2 x14_re_a2 0 1.0
Gx14_re_a2 0 x14_re_a2 p2 0 0.1414213562373095
Fx14_re_a2 0 x14_re_a2 V2 7.0710678118654755
Rp14_re_re_a2 0 x14_re_a2 1.3012613550079421e-11
Gp14_re_im_a2 0 x14_re_a2 x14_im_a2 0 55538933853.80004
Cx14_im_a2 x14_im_a2 0 1.0
Gp14_im_re_a2 0 x14_im_a2 x14_re_a2 0 -55538933853.80004
Rp14_im_im_a2 0 x14_im_a2 1.3012613550079421e-11
Cx15_a2 x15_a2 0 1.0
Gx15_a2 0 x15_a2 p2 0 0.07071067811865475
Fx15_a2 0 x15_a2 V2 3.5355339059327378
Rp15_a2 0 x15_a2 8.385580341283459e-12
Cx16_re_a2 x16_re_a2 0 1.0
Gx16_re_a2 0 x16_re_a2 p2 0 0.1414213562373095
Fx16_re_a2 0 x16_re_a2 V2 7.0710678118654755
Rp16_re_re_a2 0 x16_re_a2 1.1407048462801193e-11
Gp16_re_im_a2 0 x16_re_a2 x16_im_a2 0 45606235437.41829
Cx16_im_a2 x16_im_a2 0 1.0
Gp16_im_re_a2 0 x16_im_a2 x16_re_a2 0 -45606235437.41829
Rp16_im_im_a2 0 x16_im_a2 1.1407048462801193e-11
Cx17_re_a2 x17_re_a2 0 1.0
Gx17_re_a2 0 x17_re_a2 p2 0 0.1414213562373095
Fx17_re_a2 0 x17_re_a2 V2 7.0710678118654755
Rp17_re_re_a2 0 x17_re_a2 1.852280317388511e-11
Gp17_re_im_a2 0 x17_re_a2 x17_im_a2 0 65899210393.223076
Cx17_im_a2 x17_im_a2 0 1.0
Gp17_im_re_a2 0 x17_im_a2 x17_re_a2 0 -65899210393.223076
Rp17_im_im_a2 0 x17_im_a2 1.852280317388511e-11
Cx18_re_a2 x18_re_a2 0 1.0
Gx18_re_a2 0 x18_re_a2 p2 0 0.1414213562373095
Fx18_re_a2 0 x18_re_a2 V2 7.0710678118654755
Rp18_re_re_a2 0 x18_re_a2 2.3270679923416994e-11
Gp18_re_im_a2 0 x18_re_a2 x18_im_a2 0 70701709596.66743
Cx18_im_a2 x18_im_a2 0 1.0
Gp18_im_re_a2 0 x18_im_a2 x18_re_a2 0 -70701709596.66743
Rp18_im_im_a2 0 x18_im_a2 2.3270679923416994e-11
Cx19_re_a2 x19_re_a2 0 1.0
Gx19_re_a2 0 x19_re_a2 p2 0 0.1414213562373095
Fx19_re_a2 0 x19_re_a2 V2 7.0710678118654755
Rp19_re_re_a2 0 x19_re_a2 3.4802215599217653e-11
Gp19_re_im_a2 0 x19_re_a2 x19_im_a2 0 73499212435.46643
Cx19_im_a2 x19_im_a2 0 1.0
Gp19_im_re_a2 0 x19_im_a2 x19_re_a2 0 -73499212435.46643
Rp19_im_im_a2 0 x19_im_a2 3.4802215599217653e-11
Cx20_re_a2 x20_re_a2 0 1.0
Gx20_re_a2 0 x20_re_a2 p2 0 0.1414213562373095
Fx20_re_a2 0 x20_re_a2 V2 7.0710678118654755
Rp20_re_re_a2 0 x20_re_a2 4.919279295748042e-11
Gp20_re_im_a2 0 x20_re_a2 x20_im_a2 0 74629724773.38298
Cx20_im_a2 x20_im_a2 0 1.0
Gp20_im_re_a2 0 x20_im_a2 x20_re_a2 0 -74629724773.38298
Rp20_im_im_a2 0 x20_im_a2 4.919279295748042e-11
Cx21_re_a2 x21_re_a2 0 1.0
Gx21_re_a2 0 x21_re_a2 p2 0 0.1414213562373095
Fx21_re_a2 0 x21_re_a2 V2 7.0710678118654755
Rp21_re_re_a2 0 x21_re_a2 8.75440977265228e-11
Gp21_re_im_a2 0 x21_re_a2 x21_im_a2 0 74382551668.83495
Cx21_im_a2 x21_im_a2 0 1.0
Gp21_im_re_a2 0 x21_im_a2 x21_re_a2 0 -74382551668.83495
Rp21_im_im_a2 0 x21_im_a2 8.75440977265228e-11
Cx22_re_a2 x22_re_a2 0 1.0
Gx22_re_a2 0 x22_re_a2 p2 0 0.1414213562373095
Fx22_re_a2 0 x22_re_a2 V2 7.0710678118654755
Rp22_re_re_a2 0 x22_re_a2 1.7031651609643428e-10
Gp22_re_im_a2 0 x22_re_a2 x22_im_a2 0 73514649466.7239
Cx22_im_a2 x22_im_a2 0 1.0
Gp22_im_re_a2 0 x22_im_a2 x22_re_a2 0 -73514649466.7239
Rp22_im_im_a2 0 x22_im_a2 1.7031651609643428e-10
Cx23_re_a2 x23_re_a2 0 1.0
Gx23_re_a2 0 x23_re_a2 p2 0 0.1414213562373095
Fx23_re_a2 0 x23_re_a2 V2 7.0710678118654755
Rp23_re_re_a2 0 x23_re_a2 8.103997860421194e-10
Gp23_re_im_a2 0 x23_re_a2 x23_im_a2 0 71777301961.28047
Cx23_im_a2 x23_im_a2 0 1.0
Gp23_im_re_a2 0 x23_im_a2 x23_re_a2 0 -71777301961.28047
Rp23_im_im_a2 0 x23_im_a2 8.103997860421194e-10
Cx24_re_a2 x24_re_a2 0 1.0
Gx24_re_a2 0 x24_re_a2 p2 0 0.1414213562373095
Fx24_re_a2 0 x24_re_a2 V2 7.0710678118654755
Rp24_re_re_a2 0 x24_re_a2 3.823462806643114e-06
Gp24_re_im_a2 0 x24_re_a2 x24_im_a2 0 62894738064.385994
Cx24_im_a2 x24_im_a2 0 1.0
Gp24_im_re_a2 0 x24_im_a2 x24_re_a2 0 -62894738064.385994
Rp24_im_im_a2 0 x24_im_a2 3.823462806643114e-06
.ENDS s_equivalent
