* Three-buffer stressed PRBS7 pad-match v2
.title inv_chain PRBS7 UI=0.275ns pad_match_v2
.temp 27
.options method=gear maxord=2 reltol=1e-3 abstol=1e-9 vntol=1e-5 gmin=1e-10 trtol=10 itl4=100

Vin in_dig 0 PWL(
+ 0n 0
+ 5n 0
+ 5.05n 1.8
+ 6.925n 1.8
+ 6.975n 0
+ 8.575n 0
+ 8.625n 1.8
+ 8.85n 1.8
+ 8.9n 0
+ 10.225n 0
+ 10.275n 1.8
+ 10.775n 1.8
+ 10.825n 0
+ 11.875n 0
+ 11.925n 1.8
+ 12.15n 1.8
+ 12.2n 0
+ 12.425n 0
+ 12.475n 1.8
+ 12.7n 1.8
+ 12.75n 0
+ 13.525n 0
+ 13.575n 1.8
+ 14.625n 1.8
+ 14.675n 0
+ 15.175n 0
+ 15.225n 1.8
+ 15.45n 1.8
+ 15.5n 0
+ 16.275n 0
+ 16.325n 1.8
+ 16.55n 1.8
+ 16.6n 0
+ 16.825n 0
+ 16.875n 1.8
+ 17.375n 1.8
+ 17.425n 0
+ 17.925n 0
+ 17.975n 1.8
+ 18.75n 1.8
+ 18.8n 0
+ 19.025n 0
+ 19.075n 1.8
+ 19.3n 1.8
+ 19.35n 0
+ 19.575n 0
+ 19.625n 1.8
+ 19.85n 1.8
+ 19.9n 0
+ 20.4n 0
+ 20.45n 1.8
+ 21.775n 1.8
+ 21.825n 0
+ 22.05n 0
+ 22.1n 1.8
+ 22.325n 1.8
+ 22.375n 0
+ 23.425n 0
+ 23.475n 1.8
+ 24.25n 1.8
+ 24.3n 0
+ 25.075n 0
+ 25.125n 1.8
+ 25.35n 1.8
+ 25.4n 0
+ 25.9n 0
+ 25.95n 1.8
+ 26.175n 1.8
+ 26.225n 0
+ 26.725n 0
+ 26.775n 1.8
+ 27.275n 1.8
+ 27.325n 0
+ 27.55n 0
+ 27.6n 1.8
+ 28.1n 1.8
+ 28.15n 0
+ 28.375n 0
+ 28.425n 1.8
+ 28.65n 1.8
+ 28.7n 0
+ 28.925n 0
+ 28.975n 1.8
+ 29.475n 1.8
+ 29.525n 0
+ 29.75n 0
+ 29.8n 1.8
+ 30.85n 1.8
+ 30.9n 0
+ 31.125n 0
+ 31.175n 1.8
+ 31.675n 1.8
+ 31.725n 0
+ 32.5n 0
+ 32.55n 1.8
+ 33.05n 1.8
+ 33.1n 0
+ 33.325n 0
+ 33.375n 1.8
+ 33.6n 1.8
+ 33.65n 0
+ 34.15n 0
+ 34.2n 1.8
+ 34.425n 1.8
+ 34.475n 0
+ 34.7n 0
+ 34.75n 1.8
+ 35.525n 1.8
+ 35.575n 0
+ 35.8n 0
+ 35.85n 1.8
+ 36.625n 1.8
+ 36.675n 0
+ 37.175n 0
+ 37.225n 1.8
+ 37.725n 1.8
+ 37.775n 0
+ 38.275n 0
+ 38.325n 1.8
+ 38.55n 1.8
+ 38.6n 0
+ 38.825n 0
+ 38.875n 1.8
+ 39.1n 1.8
+ 39.15n 0
+ 39.375n 0
+ 39.425n 1.8
+ 39.65n 1.8
+ 39.7n 0
+ 39.925n 0
+ 39.975n 1.8
+ 41.85n 1.8
+ 41.9n 0
+ 43.5n 0
+ 43.55n 1.8
+ 43.775n 1.8
+ 43.825n 0
+ 45.15n 0
+ 45.2n 1.8
+ 45.7n 1.8
+ 45.75n 0
+ 46.8n 0
+ 46.85n 1.8
+ 47.075n 1.8
+ 47.125n 0
+ 47.35n 0
+ 47.4n 1.8
+ 47.625n 1.8
+ 47.675n 0
+ 48.45n 0
+ 48.5n 1.8
+ 49.55n 1.8
+ 49.6n 0
+ 50.1n 0
+ 50.15n 1.8
+ 50.375n 1.8
+ 50.425n 0
+ 51.2n 0
+ 51.25n 1.8
+ 51.475n 1.8
+ 51.525n 0
+ 51.75n 0
+ 51.8n 1.8
+ 52.3n 1.8
+ 52.35n 0
+ 52.85n 0
+ 52.9n 1.8
+ 53.675n 1.8
+ 53.725n 0
+ 53.95n 0
+ 54n 1.8
+ 54.225n 1.8
+ 54.275n 0
+ 54.5n 0
+ 54.55n 1.8
+ 54.775n 1.8
+ 54.825n 0
+ 55.325n 0
+ 55.375n 1.8
+ 56.7n 1.8
+ 56.75n 0
+ 56.975n 0
+ 57.025n 1.8
+ 57.25n 1.8
+ 57.3n 0
+ 58.35n 0
+ 58.4n 1.8
+ 59.175n 1.8
+ 59.225n 0
+ 60n 0
+ 60.05n 1.8
+ 60.275n 1.8
+ 60.325n 0
+ 60.825n 0
+ 60.875n 1.8
+ 61.1n 1.8
+ 61.15n 0
+ 61.65n 0
+ 61.7n 1.8
+ 62.2n 1.8
+ 62.25n 0
+ 62.475n 0
+ 62.525n 1.8
+ 63.025n 1.8
+ 63.075n 0
+ 63.3n 0
+ 63.35n 1.8
+ 63.575n 1.8
+ 63.625n 0
+ 63.85n 0
+ 63.9n 1.8
+ 64.4n 1.8
+ 64.45n 0
+ 64.675n 0
+ 64.725n 1.8
+ 65.775n 1.8
+ 65.825n 0
+ 66.05n 0
+ 66.1n 1.8
+ 66.6n 1.8
+ 66.65n 0
+ 67.425n 0
+ 67.475n 1.8
+ 67.975n 1.8
+ 68.025n 0
+ 68.25n 0
+ 68.3n 1.8
+ 68.525n 1.8
+ 68.575n 0
+ 69.075n 0
+ 69.125n 1.8
+ 69.35n 1.8
+ 69.4n 0
+ 69.625n 0
+ 69.675n 1.8
+ 70.45n 1.8
+ 70.5n 0
+ 70.725n 0
+ 70.775n 1.8
+ 71.55n 1.8
+ 71.6n 0
+ 72.1n 0
+ 72.15n 1.8
+ 72.65n 1.8
+ 72.7n 0
+ 73.2n 0
+ 73.25n 1.8
+ 73.475n 1.8
+ 73.525n 0
+ 73.75n 0
+ 73.8n 1.8
+ 74.025n 1.8
+ 74.075n 0
+ 74.3n 0
+ 74.35n 1.8
+ 74.575n 1.8
+ 74.625n 0
+ 74.85n 0
+ 82.85n 0 )

Ven en_sig 0 DC 1.8
Vdd vdd 0 DC 1.8
.include 'driver2_OutputInput_Typical.sub'
XDRV pad in_dig en_sig vdd 0 driver2_OutputInput_Typical
Rload pad 0 50
Cload pad 0 2p

.save V(in_dig) V(pad) V(xdrv.ku) V(xdrv.kd) V(xdrv.kuleg) V(xdrv.kdleg) V(xdrv.padsamp) V(xdrv.padstart_latch) V(xdrv.padstartspan) V(xdrv.padmatch_ambiguous) V(xdrv.pmt0) V(xdrv.pmelapsed) V(xdrv.padarg) V(xdrv.padmapactive) V(xdrv.hfall_after_rise) V(xdrv.hrise_after_fall) V(xdrv.hreverse_edge) V(xdrv.pmsample) V(xdrv.pmlatchpulse) V(xdrv.kutarget) V(xdrv.kdtarget) V(xdrv.coeff_jump_ku) V(xdrv.coeff_jump_kd)
.tran 0.005n 18.525n
.control
set filetype=binary
run
linearize
write run.raw V(in_dig) V(pad) V(xdrv.ku) V(xdrv.kd) V(xdrv.kuleg) V(xdrv.kdleg) V(xdrv.padsamp) V(xdrv.padstart_latch) V(xdrv.padstartspan) V(xdrv.padmatch_ambiguous) V(xdrv.pmt0) V(xdrv.pmelapsed) V(xdrv.padarg) V(xdrv.padmapactive) V(xdrv.hfall_after_rise) V(xdrv.hrise_after_fall) V(xdrv.hreverse_edge) V(xdrv.pmsample) V(xdrv.pmlatchpulse) V(xdrv.kutarget) V(xdrv.kdtarget) V(xdrv.coeff_jump_ku) V(xdrv.coeff_jump_kd)
quit
.endc
.end
