* Phase-1 direct-load PRBS7 HSPICE native IBIS
.title io_buf PRBS7 UI=1.75ns native IBIS
.option post=2 probe accurate ingold=2
.temp 27

Vin in_dig 0 PWL(
+ 0n 0
+ 8.75n 0
+ 8.8n 3.3
+ 21n 3.3
+ 21.05n 0
+ 31.5n 0
+ 31.55n 3.3
+ 33.25n 3.3
+ 33.3n 0
+ 42n 0
+ 42.05n 3.3
+ 45.5n 3.3
+ 45.55n 0
+ 52.5n 0
+ 52.55n 3.3
+ 54.25n 3.3
+ 54.3n 0
+ 56n 0
+ 56.05n 3.3
+ 57.75n 3.3
+ 57.8n 0
+ 63n 0
+ 63.05n 3.3
+ 70n 3.3
+ 70.05n 0
+ 73.5n 0
+ 73.55n 3.3
+ 75.25n 3.3
+ 75.3n 0
+ 80.5n 0
+ 80.55n 3.3
+ 82.25n 3.3
+ 82.3n 0
+ 84n 0
+ 84.05n 3.3
+ 87.5n 3.3
+ 87.55n 0
+ 91n 0
+ 91.05n 3.3
+ 96.25n 3.3
+ 96.3n 0
+ 98n 0
+ 98.05n 3.3
+ 99.75n 3.3
+ 99.8n 0
+ 101.5n 0
+ 101.55n 3.3
+ 103.25n 3.3
+ 103.3n 0
+ 106.75n 0
+ 106.8n 3.3
+ 115.5n 3.3
+ 115.55n 0
+ 117.25n 0
+ 117.3n 3.3
+ 119n 3.3
+ 119.05n 0
+ 126n 0
+ 126.05n 3.3
+ 131.25n 3.3
+ 131.3n 0
+ 136.5n 0
+ 136.55n 3.3
+ 138.25n 3.3
+ 138.3n 0
+ 141.75n 0
+ 141.8n 3.3
+ 143.5n 3.3
+ 143.55n 0
+ 147n 0
+ 147.05n 3.3
+ 150.5n 3.3
+ 150.55n 0
+ 152.25n 0
+ 152.3n 3.3
+ 155.75n 3.3
+ 155.8n 0
+ 157.5n 0
+ 157.55n 3.3
+ 159.25n 3.3
+ 159.3n 0
+ 161n 0
+ 161.05n 3.3
+ 164.5n 3.3
+ 164.55n 0
+ 166.25n 0
+ 166.3n 3.3
+ 173.25n 3.3
+ 173.3n 0
+ 175n 0
+ 175.05n 3.3
+ 178.5n 3.3
+ 178.55n 0
+ 183.75n 0
+ 183.8n 3.3
+ 187.25n 3.3
+ 187.3n 0
+ 189n 0
+ 189.05n 3.3
+ 190.75n 3.3
+ 190.8n 0
+ 194.25n 0
+ 194.3n 3.3
+ 196n 3.3
+ 196.05n 0
+ 197.75n 0
+ 197.8n 3.3
+ 203n 3.3
+ 203.05n 0
+ 204.75n 0
+ 204.8n 3.3
+ 210n 3.3
+ 210.05n 0
+ 213.5n 0
+ 213.55n 3.3
+ 217n 3.3
+ 217.05n 0
+ 220.5n 0
+ 220.55n 3.3
+ 222.25n 3.3
+ 222.3n 0
+ 224n 0
+ 224.05n 3.3
+ 225.75n 3.3
+ 225.8n 0
+ 227.5n 0
+ 227.55n 3.3
+ 229.25n 3.3
+ 229.3n 0
+ 231n 0
+ 231.05n 3.3
+ 243.25n 3.3
+ 243.3n 0
+ 253.75n 0
+ 253.8n 3.3
+ 255.5n 3.3
+ 255.55n 0
+ 264.25n 0
+ 264.3n 3.3
+ 267.75n 3.3
+ 267.8n 0
+ 274.75n 0
+ 274.8n 3.3
+ 276.5n 3.3
+ 276.55n 0
+ 278.25n 0
+ 278.3n 3.3
+ 280n 3.3
+ 280.05n 0
+ 285.25n 0
+ 285.3n 3.3
+ 292.25n 3.3
+ 292.3n 0
+ 295.75n 0
+ 295.8n 3.3
+ 297.5n 3.3
+ 297.55n 0
+ 302.75n 0
+ 302.8n 3.3
+ 304.5n 3.3
+ 304.55n 0
+ 306.25n 0
+ 306.3n 3.3
+ 309.75n 3.3
+ 309.8n 0
+ 313.25n 0
+ 313.3n 3.3
+ 318.5n 3.3
+ 318.55n 0
+ 320.25n 0
+ 320.3n 3.3
+ 322n 3.3
+ 322.05n 0
+ 323.75n 0
+ 323.8n 3.3
+ 325.5n 3.3
+ 325.55n 0
+ 329n 0
+ 329.05n 3.3
+ 337.75n 3.3
+ 337.8n 0
+ 339.5n 0
+ 339.55n 3.3
+ 341.25n 3.3
+ 341.3n 0
+ 348.25n 0
+ 348.3n 3.3
+ 353.5n 3.3
+ 353.55n 0
+ 358.75n 0
+ 358.8n 3.3
+ 360.5n 3.3
+ 360.55n 0
+ 364n 0
+ 364.05n 3.3
+ 365.75n 3.3
+ 365.8n 0
+ 369.25n 0
+ 369.3n 3.3
+ 372.75n 3.3
+ 372.8n 0
+ 374.5n 0
+ 374.55n 3.3
+ 378n 3.3
+ 378.05n 0
+ 379.75n 0
+ 379.8n 3.3
+ 381.5n 3.3
+ 381.55n 0
+ 383.25n 0
+ 383.3n 3.3
+ 386.75n 3.3
+ 386.8n 0
+ 388.5n 0
+ 388.55n 3.3
+ 395.5n 3.3
+ 395.55n 0
+ 397.25n 0
+ 397.3n 3.3
+ 400.75n 3.3
+ 400.8n 0
+ 406n 0
+ 406.05n 3.3
+ 409.5n 3.3
+ 409.55n 0
+ 411.25n 0
+ 411.3n 3.3
+ 413n 3.3
+ 413.05n 0
+ 416.5n 0
+ 416.55n 3.3
+ 418.25n 3.3
+ 418.3n 0
+ 420n 0
+ 420.05n 3.3
+ 425.25n 3.3
+ 425.3n 0
+ 427n 0
+ 427.05n 3.3
+ 432.25n 3.3
+ 432.3n 0
+ 435.75n 0
+ 435.8n 3.3
+ 439.25n 3.3
+ 439.3n 0
+ 442.75n 0
+ 442.8n 3.3
+ 444.5n 3.3
+ 444.55n 0
+ 446.25n 0
+ 446.3n 3.3
+ 448n 3.3
+ 448.05n 0
+ 449.75n 0
+ 449.8n 3.3
+ 451.5n 3.3
+ 451.55n 0
+ 453.25n 0
+ 474.25n 0 )

Ven en_sig 0 DC 3.3
VPU pu_ref 0 DC 3.3
VPD pd_ref 0 DC 0
VPC pc_ref 0 DC 3.3
VGC gc_ref 0 DC 0
BIBIS pu_ref pd_ref pad_ibis in_dig en_sig dig_q pc_ref gc_ref
+ file='input.ibs' model='driver' typ=typ power=off interpol=1
+ ramp_rwf=2 ramp_fwf=2 xv_pu=ku xv_pd=kd
Rdig dig_q 0 1k
Rload pad_ibis 0 50
Cload pad_ibis 0 2p

.probe tran V(in_dig) V(pad_ibis) V(ku) V(kd)
.tran 0.005n 474.25n
.end
