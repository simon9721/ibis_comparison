* ============================================================
* PRBS7 eye diagram bench — pybis2spice model
* 200 Mbps (5 ns UI), 200 bits = 1000 ns
* PRBS7 period = 127 bits -> ~1.6 complete periods
* ============================================================

.temp 27
* reltol=1e-3 is ngspice default (was 1e-4 = 10x tighter than needed)
.options method=gear maxord=2 reltol=1e-3 abstol=1e-9 vntol=1e-4 gmin=1e-12

* V-source PWL: ngspice queues breakpoints as timestep events (fast)
* Generated by scripts/gen_prbs7.py
.include 'prbs7_vstim.inc'
Ven    en_sig  0  DC 3.3
Vdd    vdd     0  DC 3.3

.include 'driver_OutputInput_Typical.sub'
XDRV  pad  in_dig  en_sig  vdd  0  driver_OutputInput_Typical

T1  pad  0  ntst  0  Z0=50 Td=30p
R1  ntst 0  50

.save V(in_dig) V(pad) V(ntst) V(xdrv.ku) V(xdrv.kd)
.tran 50p 50n

.end
