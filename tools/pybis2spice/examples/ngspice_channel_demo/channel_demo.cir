* ngspice channel demo using pybis2spice generic subcircuits
*
* This is a simple point-to-point digital channel:
*   IBIS-derived output buffer -> series resistor -> ideal T-line -> IBIS-derived input buffer
*
* The output subcircuit generated by pybis2spice is self-stimulating. It has one
* external pin, OUT, and creates its own internal Ku/Kd waveform from freq/duty.

.include HCT1G08_OUTN_50-Output-Typical-generic.sub
.include HCT1G08_IN_50-Input-Typical.sub

.param FREQ = 20Meg
.param DUTY = 0.5
.param RSER = 39
.param TD = 2n
.param ZO = 51
.param CLOAD = 2p

* Driver output buffer. One external node: drv_pad.
XDRV drv_pad HCT1G08_OUTN_50-Output-Typical params: freq={FREQ} duty={DUTY}

* Source termination and interconnect.
Rser drv_pad line_in {RSER}
Tchan line_in 0 line_out 0 Z0={ZO} TD={TD}

* Receiver input buffer. One external node: line_out.
XRCV line_out HCT1G08_IN_50-Input-Typical

* Optional extra lumped receiver/package/board capacitance.
Cload line_out 0 {CLOAD}

.control
set filetype=ascii
tran 10p 100n
plot v(drv_pad) v(line_in) v(line_out)
write channel_demo.raw v(drv_pad) v(line_in) v(line_out)
.endc

.end
